* Split-tail differential transconductor, beta multiplier, static bias decoder.
* P-bank frequency rises with VINP: the PMOS input gates are crossed at the banks.
.subckt nor2 a b y v g
Xp0 mid a v v sky130_fd_pr__pfet_01v8 w=.84 l=.15
Xp1 y b mid v sky130_fd_pr__pfet_01v8 w=.84 l=.15
Xn0 y a g g sky130_fd_pr__nfet_01v8 w=.42 l=.15
Xn1 y b g g sky130_fd_pr__nfet_01v8 w=.42 l=.15
.ends
.subckt tailgate en enb vb out v g
Xonp out enb vb v sky130_fd_pr__pfet_01v8 w=.84 l=.15
Xonn out en vb g sky130_fd_pr__nfet_01v8 w=.42 l=.15
Xoff out en v v sky130_fd_pr__pfet_01v8 w=.84 l=.15
.ends
.subckt bias b0 b1 vb g4 g15 g20 v g
* N width ratio 1:4 and matched P mirrors. Left arm sets the unit gate voltage.
Xp0 vb vb v v sky130_fd_pr__pfet_01v8 w=2 l=2
Xn0 vn vn g g sky130_fd_pr__nfet_01v8 w=2 l=2
Xp1 vn vb v v sky130_fd_pr__pfet_01v8 w=2 l=2
Xn1 vb vn rs g sky130_fd_pr__nfet_01v8 w=8 l=2
Xref0 rs refmid g sky130_fd_pr__res_high_po_0p69 l=97.1
Xref1 refmid g g sky130_fd_pr__res_high_po_0p69 l=97.1
* Pull vb down while vn is zero. After startup the LVT detector discharges kick.
Xweak kick g v v sky130_fd_pr__pfet_01v8 w=.42 l=12
Xsense kick vn g g sky130_fd_pr__nfet_01v8_lvt w=5 l=.15
Xkick vb kick g g sky130_fd_pr__nfet_01v8 w=.5 l=1
Xi0p nb0 b0 v v sky130_fd_pr__pfet_01v8 w=.84 l=.15
Xi0n nb0 b0 g g sky130_fd_pr__nfet_01v8 w=.42 l=.15
Xi1p nb1 b1 v v sky130_fd_pr__pfet_01v8 w=.84 l=.15
Xi1n nb1 b1 g g sky130_fd_pr__nfet_01v8 w=.42 l=.15
Xonlylow nb0 b1 off4 v g nor2
Xi4p en4 off4 v v sky130_fd_pr__pfet_01v8 w=.84 l=.15
Xi4n en4 off4 g g sky130_fd_pr__nfet_01v8 w=.42 l=.15
Xboth nb0 nb1 en20 v g nor2
Xzero b0 b1 zero v g nor2
Xdiff zero en20 off15 v g nor2
Xi15p en15 off15 v v sky130_fd_pr__pfet_01v8 w=.84 l=.15
Xi15n en15 off15 g g sky130_fd_pr__nfet_01v8 w=.42 l=.15
Xi20p off20 en20 v v sky130_fd_pr__pfet_01v8 w=.84 l=.15
Xi20n off20 en20 g g sky130_fd_pr__nfet_01v8 w=.42 l=.15
Xsw4 en4 off4 vb g4 v g tailgate
Xsw15 en15 off15 vb g15 v g tailgate
Xsw20 en20 off20 vb g20 v g tailgate
.ends
.subckt tail s vb g4 g15 g20 v
Xone s vb v v sky130_fd_pr__pfet_01v8 w=1 l=2
Xg4_1 s g4 v v sky130_fd_pr__pfet_01v8 w=1 l=2
Xg4_2 s g4 v v sky130_fd_pr__pfet_01v8 w=1 l=2
Xg4_3 s g4 v v sky130_fd_pr__pfet_01v8 w=1 l=2
Xg4_4 s g4 v v sky130_fd_pr__pfet_01v8 w=1 l=2
Xg15_1 s g15 v v sky130_fd_pr__pfet_01v8 w=1 l=2
Xg15_2 s g15 v v sky130_fd_pr__pfet_01v8 w=1 l=2
Xg15_3 s g15 v v sky130_fd_pr__pfet_01v8 w=1 l=2
Xg15_4 s g15 v v sky130_fd_pr__pfet_01v8 w=1 l=2
Xg15_5 s g15 v v sky130_fd_pr__pfet_01v8 w=1 l=2
Xg15_6 s g15 v v sky130_fd_pr__pfet_01v8 w=1 l=2
Xg15_7 s g15 v v sky130_fd_pr__pfet_01v8 w=1 l=2
Xg15_8 s g15 v v sky130_fd_pr__pfet_01v8 w=1 l=2
Xg15_9 s g15 v v sky130_fd_pr__pfet_01v8 w=1 l=2
Xg15_10 s g15 v v sky130_fd_pr__pfet_01v8 w=1 l=2
Xg15_11 s g15 v v sky130_fd_pr__pfet_01v8 w=1 l=2
Xg15_12 s g15 v v sky130_fd_pr__pfet_01v8 w=1 l=2
Xg15_13 s g15 v v sky130_fd_pr__pfet_01v8 w=1 l=2
Xg15_14 s g15 v v sky130_fd_pr__pfet_01v8 w=1 l=2
Xg15_15 s g15 v v sky130_fd_pr__pfet_01v8 w=1 l=2
Xg20_1 s g20 v v sky130_fd_pr__pfet_01v8 w=1 l=2
Xg20_2 s g20 v v sky130_fd_pr__pfet_01v8 w=1 l=2
Xg20_3 s g20 v v sky130_fd_pr__pfet_01v8 w=1 l=2
Xg20_4 s g20 v v sky130_fd_pr__pfet_01v8 w=1 l=2
Xg20_5 s g20 v v sky130_fd_pr__pfet_01v8 w=1 l=2
Xg20_6 s g20 v v sky130_fd_pr__pfet_01v8 w=1 l=2
Xg20_7 s g20 v v sky130_fd_pr__pfet_01v8 w=1 l=2
Xg20_8 s g20 v v sky130_fd_pr__pfet_01v8 w=1 l=2
Xg20_9 s g20 v v sky130_fd_pr__pfet_01v8 w=1 l=2
Xg20_10 s g20 v v sky130_fd_pr__pfet_01v8 w=1 l=2
Xg20_11 s g20 v v sky130_fd_pr__pfet_01v8 w=1 l=2
Xg20_12 s g20 v v sky130_fd_pr__pfet_01v8 w=1 l=2
Xg20_13 s g20 v v sky130_fd_pr__pfet_01v8 w=1 l=2
Xg20_14 s g20 v v sky130_fd_pr__pfet_01v8 w=1 l=2
Xg20_15 s g20 v v sky130_fd_pr__pfet_01v8 w=1 l=2
Xg20_16 s g20 v v sky130_fd_pr__pfet_01v8 w=1 l=2
Xg20_17 s g20 v v sky130_fd_pr__pfet_01v8 w=1 l=2
Xg20_18 s g20 v v sky130_fd_pr__pfet_01v8 w=1 l=2
Xg20_19 s g20 v v sky130_fd_pr__pfet_01v8 w=1 l=2
Xg20_20 s g20 v v sky130_fd_pr__pfet_01v8 w=1 l=2
.ends
.subckt front vinp vinn b0 b1 rp rn v g
Xbias b0 b1 vb g4 g15 g20 v g bias
Xtailp sp vb g4 g15 g20 v tail
Xtailn sn vb g4 g15 g20 v tail
Xinp0 rp vinn sp sp sky130_fd_pr__pfet_01v8_lvt w=6 l=1
Xinp1 rp vinn sp sp sky130_fd_pr__pfet_01v8_lvt w=6 l=1
Xinp2 rp vinn sp sp sky130_fd_pr__pfet_01v8_lvt w=6 l=1
Xinp3 rp vinn sp sp sky130_fd_pr__pfet_01v8_lvt w=6 l=1
Xinn0 rn vinp sn sn sky130_fd_pr__pfet_01v8_lvt w=6 l=1
Xinn1 rn vinp sn sn sky130_fd_pr__pfet_01v8_lvt w=6 l=1
Xinn2 rn vinp sn sn sky130_fd_pr__pfet_01v8_lvt w=6 l=1
Xinn3 rn vinp sn sn sky130_fd_pr__pfet_01v8_lvt w=6 l=1
Xr0 sp mid g sky130_fd_pr__res_high_po_0p69 l=80
Xr1 mid sn g sky130_fd_pr__res_high_po_0p69 l=80
XcapP rp g sky130_fd_pr__cap_mim_m3_1 w=21.8 l=21.8
XcapN rn g sky130_fd_pr__cap_mim_m3_1 w=21.8 l=21.8
.ends front
.subckt stage a b y z rail g well
Xca g y sky130_fd_pr__cap_mim_m3_1 w=4.5 l=4.5
Xcb g z sky130_fd_pr__cap_mim_m3_1 w=4.5 l=4.5
XmainA_Xp y a rail well sky130_fd_pr__pfet_01v8_lvt w=8.4 l=.55
XmainA_Xn y a g g sky130_fd_pr__nfet_01v8 w=4.2 l=.55
XmainB_Xp z b rail well sky130_fd_pr__pfet_01v8_lvt w=8.4 l=.55
XmainB_Xn z b g g sky130_fd_pr__nfet_01v8 w=4.2 l=.55
XcrossA_Xp z y rail well sky130_fd_pr__pfet_01v8_lvt w=1.68 l=.55
XcrossA_Xn z y g g sky130_fd_pr__nfet_01v8 w=.84 l=.55
XcrossB_Xp y z rail well sky130_fd_pr__pfet_01v8_lvt w=1.68 l=.55
XcrossB_Xn y z g g sky130_fd_pr__nfet_01v8 w=.84 l=.55
.ends stage

.subckt bank rail well g oa0 ob0 oa1 ob1 oa2 ob2 oa3 ob3 oa4 ob4 oa5 ob5 oa6 ob6 oa7 ob7 oa8 ob8 oa9 ob9 oa10 ob10 oa11 ob11 oa12 ob12 oa13 ob13 oa14 ob14
X0 oa14 ob14 oa0 ob0 rail g well stage
X1 oa0 ob0 oa1 ob1 rail g well stage
X2 oa1 ob1 oa2 ob2 rail g well stage
X3 oa2 ob2 oa3 ob3 rail g well stage
X4 oa3 ob3 oa4 ob4 rail g well stage
X5 oa4 ob4 oa5 ob5 rail g well stage
X6 oa5 ob5 oa6 ob6 rail g well stage
X7 oa6 ob6 oa7 ob7 rail g well stage
X8 oa7 ob7 oa8 ob8 rail g well stage
X9 oa8 ob8 oa9 ob9 rail g well stage
X10 oa9 ob9 oa10 ob10 rail g well stage
X11 oa10 ob10 oa11 ob11 rail g well stage
X12 oa11 ob11 oa12 ob12 rail g well stage
X13 oa12 ob12 oa13 ob13 rail g well stage
X14 oa13 ob13 oa14 ob14 rail g well stage
Xdummy well well dy dz g g well stage
.ends bank

.subckt cvsl a b out v g
Xn0 l a g g sky130_fd_pr__nfet_01v8_lvt w=4 l=.15 ad=1.16 as=1.16 pd=8.58 ps=8.58
Xn1 r b g g sky130_fd_pr__nfet_01v8_lvt w=4 l=.15 ad=1.16 as=1.16 pd=8.58 ps=8.58
Xp0 l r v v sky130_fd_pr__pfet_01v8 w=.42 l=2.4 ad=.122 as=.122 pd=1.42 ps=1.42
Xp1 r l v v sky130_fd_pr__pfet_01v8 w=.42 l=2.4 ad=.122 as=.122 pd=1.42 ps=1.42
Xbuf_p out l v v sky130_fd_pr__pfet_01v8 w=.84 l=.15
Xbuf_n out l g g sky130_fd_pr__nfet_01v8 w=.42 l=.15
Xdummy_p dummy r v v sky130_fd_pr__pfet_01v8 w=.84 l=.15
Xdummy_n dummy r g g sky130_fd_pr__nfet_01v8 w=.42 l=.15
.ends

.subckt ring rail v g t0 t1 t2 t3 t4 t5 t6 t7 t8 t9 t10 t11 t12 t13 t14
Xbank rail v g oa0 ob0 oa1 ob1 oa2 ob2 oa3 ob3 oa4 ob4 oa5 ob5 oa6 ob6 oa7 ob7 oa8 ob8 oa9 ob9 oa10 ob10 oa11 ob11 oa12 ob12 oa13 ob13 oa14 ob14 bank
Xl0 oa0 ob0 t0 v g cvsl
Xl1 oa1 ob1 t1 v g cvsl
Xl2 oa2 ob2 t2 v g cvsl
Xl3 oa3 ob3 t3 v g cvsl
Xl4 oa4 ob4 t4 v g cvsl
Xl5 oa5 ob5 t5 v g cvsl
Xl6 oa6 ob6 t6 v g cvsl
Xl7 oa7 ob7 t7 v g cvsl
Xl8 oa8 ob8 t8 v g cvsl
Xl9 oa9 ob9 t9 v g cvsl
Xl10 oa10 ob10 t10 v g cvsl
Xl11 oa11 ob11 t11 v g cvsl
Xl12 oa12 ob12 t12 v g cvsl
Xl13 oa13 ob13 t13 v g cvsl
Xl14 oa14 ob14 t14 v g cvsl
.ends ring

.subckt dual rp rn v g p0 p1 p2 p3 p4 p5 p6 p7 p8 p9 p10 p11 p12 p13 p14 n0 n1 n2 n3 n4 n5 n6 n7 n8 n9 n10 n11 n12 n13 n14
Xp rp v g p0 p1 p2 p3 p4 p5 p6 p7 p8 p9 p10 p11 p12 p13 p14 ring
Xn rn v g n0 n1 n2 n3 n4 n5 n6 n7 n8 n9 n10 n11 n12 n13 n14 ring
.ends dual
.subckt adc_analog vinp vinn b0 b1 v g p0 p1 p2 p3 p4 p5 p6 p7 p8 p9 p10 p11 p12 p13 p14 n0 n1 n2 n3 n4 n5 n6 n7 n8 n9 n10 n11 n12 n13 n14
Xf vinp vinn b0 b1 rp rn v g front
Xd rp rn v g p0 p1 p2 p3 p4 p5 p6 p7 p8 p9 p10 p11 p12 p13 p14 n0 n1 n2 n3 n4 n5 n6 n7 n8 n9 n10 n11 n12 n13 n14 dual
.ends adc_analog
