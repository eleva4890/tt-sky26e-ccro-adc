* Final tile routing and receiver-metal capacitance, fF. Receiver transistor load is separate.
Cio1 0 n0 7.8897260f
Cio2 0 n1 4.0834922f
Cio3 0 n10 4.7095940f
Cio4 0 n11 3.6628756f
Cio5 0 n12 6.5309507f
Cio6 0 n13 6.9424546f
Cio7 0 n14 6.3899220f
Cio8 0 n2 3.3099947f
Cio9 0 n3 4.7636081f
Cio10 0 n4 3.2863675f
Cio11 0 n5 3.5248606f
Cio12 0 n6 2.6233916f
Cio13 0 n7 3.9574533f
Cio14 0 n8 4.6608680f
Cio15 0 n9 3.3660238f
Cio16 0 p0 6.1575778f
Cio17 0 p1 2.8909669f
Cio18 0 p10 4.7478781f
Cio19 0 p11 4.4148917f
Cio20 0 p12 3.9880956f
Cio21 0 p13 3.1272176f
Cio22 0 p14 3.1902062f
Cio23 0 p2 3.7558629f
Cio24 0 p3 2.8664477f
Cio25 0 p4 3.9221383f
Cio26 0 p5 3.8661440f
Cio27 0 p6 2.7825919f
Cio28 0 p7 4.2325765f
Cio29 0 p8 3.8749305f
Cio30 0 p9 3.7446268f
Cio31 n0 n1 0.1292570f
Cio32 n0 n2 0.0014424f
Cio33 n0 p14 0.0894040f
Cio34 n1 n2 0.2561130f
Cio35 n1 n3 0.0123051f
Cio36 n1 n4 0.0004043f
Cio37 n1 p14 0.0244659f
Cio38 n10 n11 0.3523240f
Cio39 n10 n12 0.0636915f
Cio40 n10 n13 0.0131241f
Cio41 n10 n7 0.0006228f
Cio42 n10 n8 0.0362392f
Cio43 n10 n9 0.5169010f
Cio44 n11 n12 0.2971710f
Cio45 n11 n13 0.0427726f
Cio46 n11 n14 0.0007019f
Cio47 n11 n8 0.0009726f
Cio48 n11 n9 0.0733118f
Cio49 n12 n13 0.1843450f
Cio50 n12 n14 0.0443660f
Cio51 n12 n8 0.0000060f
Cio52 n12 n9 0.0007509f
Cio53 n13 n14 0.3212930f
Cio54 n2 n3 0.1429030f
Cio55 n2 n4 0.0098939f
Cio56 n2 p14 0.0001649f
Cio57 n3 n4 0.2478910f
Cio58 n3 n5 0.1042790f
Cio59 n3 n6 0.0004786f
Cio60 n4 n5 0.2104190f
Cio61 n4 n6 0.0186526f
Cio62 n5 n6 0.2735340f
Cio63 n5 n7 0.0174134f
Cio64 n5 n8 0.0005487f
Cio65 n6 n7 0.1570420f
Cio66 n6 n8 0.0196784f
Cio67 n7 n8 0.4950080f
Cio68 n7 n9 0.0275411f
Cio69 n8 n9 0.1720790f
Cio70 p0 p1 0.2890370f
Cio71 p0 p2 0.0174627f
Cio72 p0 p3 0.0005218f
Cio73 p1 p2 0.1785660f
Cio74 p1 p3 0.0158915f
Cio75 p10 p11 0.1164540f
Cio76 p10 p12 0.0007964f
Cio77 p10 p13 0.0033968f
Cio78 p10 p8 0.0049421f
Cio79 p10 p9 0.1236850f
Cio80 p11 p12 0.1362080f
Cio81 p11 p9 0.0000029f
Cio82 p12 p13 0.1994630f
Cio83 p12 p14 0.0002663f
Cio84 p12 p9 0.0011456f
Cio85 p13 p14 0.0946080f
Cio86 p2 p3 0.2690180f
Cio87 p2 p4 0.0125913f
Cio88 p2 p5 0.0032056f
Cio89 p3 p4 0.1272160f
Cio90 p3 p5 0.0206119f
Cio91 p4 p5 0.3160790f
Cio92 p4 p6 0.0095762f
Cio93 p4 p7 0.0013521f
Cio94 p5 p6 0.1453050f
Cio95 p5 p7 0.0092586f
Cio96 p6 p7 0.2397830f
Cio97 p6 p8 0.0089079f
Cio98 p6 p9 0.0003911f
Cio99 p7 p8 0.2256500f
Cio100 p7 p9 0.0097597f
Cio101 p8 p9 0.2602340f
