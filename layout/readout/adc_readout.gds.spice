* NGSPICE file created from adc_readout.ext - technology: sky130A

.subckt sky130_fd_sc_hd__decap_3 VPWR VGND VPB VNB
X0 VPWR VGND VPWR VPB sky130_fd_pr__pfet_01v8_hvt ad=0.226 pd=2.26 as=0 ps=0 w=0.87 l=0.59
X1 VGND VPWR VGND VNB sky130_fd_pr__nfet_01v8 ad=0.143 pd=1.62 as=0 ps=0 w=0.55 l=0.59
.ends

.subckt sky130_fd_sc_hd__diode_2 DIODE VGND VPWR VPB VNB
X0 VNB DIODE sky130_fd_pr__diode_pw2nd_05v5 perim=2.64e+06 area=4.347e+11
.ends

.subckt sky130_fd_sc_hd__dfxtp_1 Q CLK D VPB VNB VPWR VGND
X0 Q a_1059_315# VGND VNB sky130_fd_pr__nfet_01v8 ad=0.169 pd=1.82 as=0.0878 ps=0.92 w=0.65 l=0.15
X1 a_891_413# a_193_47# a_634_159# VNB sky130_fd_pr__special_nfet_01v8 ad=0.0684 pd=0.74 as=0.0989 ps=0.995 w=0.36 l=0.15
X2 a_561_413# a_27_47# a_466_413# VPB sky130_fd_pr__pfet_01v8_hvt ad=0.0767 pd=0.785 as=0.0683 ps=0.745 w=0.42 l=0.15
X3 VPWR CLK a_27_47# VPB sky130_fd_pr__pfet_01v8_hvt ad=0.0864 pd=0.91 as=0.166 ps=1.8 w=0.64 l=0.15
X4 Q a_1059_315# VPWR VPB sky130_fd_pr__pfet_01v8_hvt ad=0.26 pd=2.52 as=0.135 ps=1.27 w=1 l=0.15
X5 a_381_47# D VPWR VPB sky130_fd_pr__pfet_01v8_hvt ad=0.0578 pd=0.695 as=0.109 ps=1.36 w=0.42 l=0.15
X6 VGND a_634_159# a_592_47# VNB sky130_fd_pr__nfet_01v8 ad=0.121 pd=1.09 as=0.0696 ps=0.765 w=0.42 l=0.15
X7 VPWR a_891_413# a_1059_315# VPB sky130_fd_pr__pfet_01v8_hvt ad=0.135 pd=1.27 as=0.27 ps=2.54 w=1 l=0.15
X8 a_466_413# a_193_47# a_381_47# VPB sky130_fd_pr__pfet_01v8_hvt ad=0.0683 pd=0.745 as=0.0578 ps=0.695 w=0.42 l=0.15
X9 VPWR a_634_159# a_561_413# VPB sky130_fd_pr__pfet_01v8_hvt ad=0.179 pd=1.26 as=0.0767 ps=0.785 w=0.42 l=0.15
X10 a_634_159# a_466_413# VGND VNB sky130_fd_pr__nfet_01v8 ad=0.0989 pd=0.995 as=0.121 ps=1.09 w=0.64 l=0.15
X11 a_634_159# a_466_413# VPWR VPB sky130_fd_pr__pfet_01v8_hvt ad=0.109 pd=1.08 as=0.179 ps=1.26 w=0.75 l=0.15
X12 a_975_413# a_193_47# a_891_413# VPB sky130_fd_pr__pfet_01v8_hvt ad=0.0882 pd=0.84 as=0.0567 ps=0.69 w=0.42 l=0.15
X13 VGND a_1059_315# a_1017_47# VNB sky130_fd_pr__nfet_01v8 ad=0.109 pd=1.36 as=0.066 ps=0.745 w=0.42 l=0.15
X14 a_193_47# a_27_47# VGND VNB sky130_fd_pr__nfet_01v8 ad=0.109 pd=1.36 as=0.0567 ps=0.69 w=0.42 l=0.15
X15 a_891_413# a_27_47# a_634_159# VPB sky130_fd_pr__pfet_01v8_hvt ad=0.0567 pd=0.69 as=0.109 ps=1.08 w=0.42 l=0.15
X16 a_592_47# a_193_47# a_466_413# VNB sky130_fd_pr__special_nfet_01v8 ad=0.0696 pd=0.765 as=0.0621 ps=0.705 w=0.36 l=0.15
X17 VPWR a_1059_315# a_975_413# VPB sky130_fd_pr__pfet_01v8_hvt ad=0.111 pd=1.37 as=0.0882 ps=0.84 w=0.42 l=0.15
X18 a_1017_47# a_27_47# a_891_413# VNB sky130_fd_pr__special_nfet_01v8 ad=0.066 pd=0.745 as=0.0684 ps=0.74 w=0.36 l=0.15
X19 a_193_47# a_27_47# VPWR VPB sky130_fd_pr__pfet_01v8_hvt ad=0.166 pd=1.8 as=0.0864 ps=0.91 w=0.64 l=0.15
X20 a_466_413# a_27_47# a_381_47# VNB sky130_fd_pr__special_nfet_01v8 ad=0.0621 pd=0.705 as=0.0813 ps=0.83 w=0.36 l=0.15
X21 VGND a_891_413# a_1059_315# VNB sky130_fd_pr__nfet_01v8 ad=0.0878 pd=0.92 as=0.169 ps=1.82 w=0.65 l=0.15
X22 a_381_47# D VGND VNB sky130_fd_pr__nfet_01v8 ad=0.0813 pd=0.83 as=0.109 ps=1.36 w=0.42 l=0.15
X23 VGND CLK a_27_47# VNB sky130_fd_pr__nfet_01v8 ad=0.0567 pd=0.69 as=0.109 ps=1.36 w=0.42 l=0.15
.ends

.subckt sky130_fd_sc_hd__dfrtp_1 VGND VPWR VPB VNB CLK D RESET_B Q
X0 a_805_47# a_761_289# a_639_47# VNB sky130_fd_pr__nfet_01v8 ad=0.0441 pd=0.63 as=0.14 ps=1.1 w=0.42 l=0.15
X1 a_1217_47# a_27_47# a_1108_47# VNB sky130_fd_pr__special_nfet_01v8 ad=0.0669 pd=0.75 as=0.0711 ps=0.755 w=0.36 l=0.15
X2 a_1283_21# a_1108_47# a_1462_47# VNB sky130_fd_pr__nfet_01v8 ad=0.109 pd=1.36 as=0.064 ps=0.725 w=0.42 l=0.15
X3 a_651_413# a_27_47# a_543_47# VPB sky130_fd_pr__pfet_01v8_hvt ad=0.116 pd=0.97 as=0.0724 ps=0.765 w=0.42 l=0.15
X4 a_1108_47# a_193_47# a_761_289# VNB sky130_fd_pr__special_nfet_01v8 ad=0.0711 pd=0.755 as=0.0999 ps=0.985 w=0.36 l=0.15
X5 VGND RESET_B a_805_47# VNB sky130_fd_pr__nfet_01v8 ad=0.135 pd=1.15 as=0.0441 ps=0.63 w=0.42 l=0.15
X6 Q a_1283_21# VPWR VPB sky130_fd_pr__pfet_01v8_hvt ad=0.26 pd=2.52 as=0.301 ps=2.66 w=1 l=0.15
X7 VPWR CLK a_27_47# VPB sky130_fd_pr__pfet_01v8_hvt ad=0.0864 pd=0.91 as=0.166 ps=1.8 w=0.64 l=0.15
X8 a_448_47# D VPWR VPB sky130_fd_pr__pfet_01v8_hvt ad=0.0651 pd=0.73 as=0.109 ps=1.36 w=0.42 l=0.15
X9 a_761_289# a_543_47# VGND VNB sky130_fd_pr__nfet_01v8 ad=0.0999 pd=0.985 as=0.135 ps=1.15 w=0.64 l=0.15
X10 a_193_47# a_27_47# VGND VNB sky130_fd_pr__nfet_01v8 ad=0.109 pd=1.36 as=0.0567 ps=0.69 w=0.42 l=0.15
X11 a_1108_47# a_27_47# a_761_289# VPB sky130_fd_pr__pfet_01v8_hvt ad=0.0588 pd=0.7 as=0.129 ps=1.18 w=0.42 l=0.15
X12 a_1462_47# RESET_B VGND VNB sky130_fd_pr__nfet_01v8 ad=0.064 pd=0.725 as=0.125 ps=1.01 w=0.42 l=0.15
X13 a_543_47# a_27_47# a_448_47# VNB sky130_fd_pr__special_nfet_01v8 ad=0.0594 pd=0.69 as=0.066 ps=0.745 w=0.36 l=0.15
X14 a_543_47# a_193_47# a_448_47# VPB sky130_fd_pr__pfet_01v8_hvt ad=0.0724 pd=0.765 as=0.0651 ps=0.73 w=0.42 l=0.15
X15 a_448_47# D VGND VNB sky130_fd_pr__nfet_01v8 ad=0.066 pd=0.745 as=0.221 ps=1.89 w=0.42 l=0.15
X16 VPWR a_1283_21# a_1270_413# VPB sky130_fd_pr__pfet_01v8_hvt ad=0.0819 pd=0.81 as=0.0567 ps=0.69 w=0.42 l=0.15
X17 VPWR a_1108_47# a_1283_21# VPB sky130_fd_pr__pfet_01v8_hvt ad=0.113 pd=1.38 as=0.0567 ps=0.69 w=0.42 l=0.15
X18 a_1270_413# a_193_47# a_1108_47# VPB sky130_fd_pr__pfet_01v8_hvt ad=0.0567 pd=0.69 as=0.0588 ps=0.7 w=0.42 l=0.15
X19 a_193_47# a_27_47# VPWR VPB sky130_fd_pr__pfet_01v8_hvt ad=0.166 pd=1.8 as=0.0864 ps=0.91 w=0.64 l=0.15
X20 a_1283_21# RESET_B VPWR VPB sky130_fd_pr__pfet_01v8_hvt ad=0.0567 pd=0.69 as=0.0819 ps=0.81 w=0.42 l=0.15
X21 VPWR a_761_289# a_651_413# VPB sky130_fd_pr__pfet_01v8_hvt ad=0.0703 pd=0.755 as=0.116 ps=0.97 w=0.42 l=0.15
X22 Q a_1283_21# VGND VNB sky130_fd_pr__nfet_01v8 ad=0.169 pd=1.82 as=0.209 ps=2.02 w=0.65 l=0.15
X23 a_639_47# a_193_47# a_543_47# VNB sky130_fd_pr__special_nfet_01v8 ad=0.14 pd=1.1 as=0.0594 ps=0.69 w=0.36 l=0.15
X24 VGND a_1283_21# a_1217_47# VNB sky130_fd_pr__nfet_01v8 ad=0.125 pd=1.01 as=0.0669 ps=0.75 w=0.42 l=0.15
X25 a_651_413# RESET_B VPWR VPB sky130_fd_pr__pfet_01v8_hvt ad=0.109 pd=1.36 as=0.0703 ps=0.755 w=0.42 l=0.15
X26 VGND CLK a_27_47# VNB sky130_fd_pr__nfet_01v8 ad=0.0567 pd=0.69 as=0.109 ps=1.36 w=0.42 l=0.15
X27 a_761_289# a_543_47# VPWR VPB sky130_fd_pr__pfet_01v8_hvt ad=0.129 pd=1.18 as=0.218 ps=2.2 w=0.84 l=0.15
.ends

.subckt sky130_fd_sc_hd__dfrtp_4 VGND VPWR VPB VNB CLK D RESET_B Q
X0 a_805_47# a_761_289# a_639_47# VNB sky130_fd_pr__nfet_01v8 ad=0.0441 pd=0.63 as=0.14 ps=1.1 w=0.42 l=0.15
X1 a_1217_47# a_27_47# a_1108_47# VNB sky130_fd_pr__special_nfet_01v8 ad=0.0669 pd=0.75 as=0.0711 ps=0.755 w=0.36 l=0.15
X2 a_1283_21# a_1108_47# a_1462_47# VNB sky130_fd_pr__nfet_01v8 ad=0.109 pd=1.36 as=0.064 ps=0.725 w=0.42 l=0.15
X3 a_651_413# a_27_47# a_543_47# VPB sky130_fd_pr__pfet_01v8_hvt ad=0.116 pd=0.97 as=0.0724 ps=0.765 w=0.42 l=0.15
X4 a_1108_47# a_193_47# a_761_289# VNB sky130_fd_pr__special_nfet_01v8 ad=0.0711 pd=0.755 as=0.0999 ps=0.985 w=0.36 l=0.15
X5 VGND RESET_B a_805_47# VNB sky130_fd_pr__nfet_01v8 ad=0.135 pd=1.15 as=0.0441 ps=0.63 w=0.42 l=0.15
X6 VPWR a_1283_21# Q VPB sky130_fd_pr__pfet_01v8_hvt ad=0.305 pd=2.61 as=0.135 ps=1.27 w=1 l=0.15
X7 VPWR CLK a_27_47# VPB sky130_fd_pr__pfet_01v8_hvt ad=0.0864 pd=0.91 as=0.166 ps=1.8 w=0.64 l=0.15
X8 a_448_47# D VPWR VPB sky130_fd_pr__pfet_01v8_hvt ad=0.0651 pd=0.73 as=0.109 ps=1.36 w=0.42 l=0.15
X9 Q a_1283_21# VPWR VPB sky130_fd_pr__pfet_01v8_hvt ad=0.135 pd=1.27 as=0.135 ps=1.27 w=1 l=0.15
X10 VPWR a_1283_21# Q VPB sky130_fd_pr__pfet_01v8_hvt ad=0.135 pd=1.27 as=0.135 ps=1.27 w=1 l=0.15
X11 a_761_289# a_543_47# VGND VNB sky130_fd_pr__nfet_01v8 ad=0.0999 pd=0.985 as=0.135 ps=1.15 w=0.64 l=0.15
X12 Q a_1283_21# VGND VNB sky130_fd_pr__nfet_01v8 ad=0.0878 pd=0.92 as=0.169 ps=1.82 w=0.65 l=0.15
X13 a_193_47# a_27_47# VGND VNB sky130_fd_pr__nfet_01v8 ad=0.109 pd=1.36 as=0.0567 ps=0.69 w=0.42 l=0.15
X14 a_1108_47# a_27_47# a_761_289# VPB sky130_fd_pr__pfet_01v8_hvt ad=0.0588 pd=0.7 as=0.129 ps=1.18 w=0.42 l=0.15
X15 a_1462_47# RESET_B VGND VNB sky130_fd_pr__nfet_01v8 ad=0.064 pd=0.725 as=0.125 ps=1.01 w=0.42 l=0.15
X16 a_543_47# a_27_47# a_448_47# VNB sky130_fd_pr__special_nfet_01v8 ad=0.0594 pd=0.69 as=0.066 ps=0.745 w=0.36 l=0.15
X17 a_543_47# a_193_47# a_448_47# VPB sky130_fd_pr__pfet_01v8_hvt ad=0.0724 pd=0.765 as=0.0651 ps=0.73 w=0.42 l=0.15
X18 a_448_47# D VGND VNB sky130_fd_pr__nfet_01v8 ad=0.066 pd=0.745 as=0.221 ps=1.89 w=0.42 l=0.15
X19 VPWR a_1283_21# a_1270_413# VPB sky130_fd_pr__pfet_01v8_hvt ad=0.0819 pd=0.81 as=0.0567 ps=0.69 w=0.42 l=0.15
X20 VPWR a_1108_47# a_1283_21# VPB sky130_fd_pr__pfet_01v8_hvt ad=0.113 pd=1.38 as=0.0567 ps=0.69 w=0.42 l=0.15
X21 Q a_1283_21# VPWR VPB sky130_fd_pr__pfet_01v8_hvt ad=0.135 pd=1.27 as=0.26 ps=2.52 w=1 l=0.15
X22 a_1270_413# a_193_47# a_1108_47# VPB sky130_fd_pr__pfet_01v8_hvt ad=0.0567 pd=0.69 as=0.0588 ps=0.7 w=0.42 l=0.15
X23 a_193_47# a_27_47# VPWR VPB sky130_fd_pr__pfet_01v8_hvt ad=0.166 pd=1.8 as=0.0864 ps=0.91 w=0.64 l=0.15
X24 a_1283_21# RESET_B VPWR VPB sky130_fd_pr__pfet_01v8_hvt ad=0.0567 pd=0.69 as=0.0819 ps=0.81 w=0.42 l=0.15
X25 VGND a_1283_21# Q VNB sky130_fd_pr__nfet_01v8 ad=0.0878 pd=0.92 as=0.0878 ps=0.92 w=0.65 l=0.15
X26 VGND a_1283_21# Q VNB sky130_fd_pr__nfet_01v8 ad=0.182 pd=1.86 as=0.0878 ps=0.92 w=0.65 l=0.15
X27 VPWR a_761_289# a_651_413# VPB sky130_fd_pr__pfet_01v8_hvt ad=0.0703 pd=0.755 as=0.116 ps=0.97 w=0.42 l=0.15
X28 a_639_47# a_193_47# a_543_47# VNB sky130_fd_pr__special_nfet_01v8 ad=0.14 pd=1.1 as=0.0594 ps=0.69 w=0.36 l=0.15
X29 VGND a_1283_21# a_1217_47# VNB sky130_fd_pr__nfet_01v8 ad=0.125 pd=1.01 as=0.0669 ps=0.75 w=0.42 l=0.15
X30 a_651_413# RESET_B VPWR VPB sky130_fd_pr__pfet_01v8_hvt ad=0.109 pd=1.36 as=0.0703 ps=0.755 w=0.42 l=0.15
X31 VGND CLK a_27_47# VNB sky130_fd_pr__nfet_01v8 ad=0.0567 pd=0.69 as=0.109 ps=1.36 w=0.42 l=0.15
X32 a_761_289# a_543_47# VPWR VPB sky130_fd_pr__pfet_01v8_hvt ad=0.129 pd=1.18 as=0.218 ps=2.2 w=0.84 l=0.15
X33 Q a_1283_21# VGND VNB sky130_fd_pr__nfet_01v8 ad=0.0878 pd=0.92 as=0.0878 ps=0.92 w=0.65 l=0.15
.ends

.subckt sky130_fd_sc_hd__fa_1 VPB VNB VGND VPWR B COUT A CIN SUM
X0 a_76_199# B a_208_47# VNB sky130_fd_pr__nfet_01v8 ad=0.0567 pd=0.69 as=0.063 ps=0.72 w=0.42 l=0.15
X1 VGND A a_382_47# VNB sky130_fd_pr__nfet_01v8 ad=0.0567 pd=0.69 as=0.0567 ps=0.69 w=0.42 l=0.15
X2 a_738_413# A VPWR VPB sky130_fd_pr__pfet_01v8_hvt ad=0.0619 pd=0.715 as=0.0567 ps=0.69 w=0.42 l=0.15
X3 a_1091_47# CIN a_995_47# VNB sky130_fd_pr__nfet_01v8 ad=0.0441 pd=0.63 as=0.0693 ps=0.75 w=0.42 l=0.15
X4 VPWR CIN a_738_413# VPB sky130_fd_pr__pfet_01v8_hvt ad=0.0567 pd=0.69 as=0.0567 ps=0.69 w=0.42 l=0.15
X5 a_382_413# B VPWR VPB sky130_fd_pr__pfet_01v8_hvt ad=0.109 pd=1.36 as=0.0567 ps=0.69 w=0.42 l=0.15
X6 a_1163_47# B a_1091_47# VNB sky130_fd_pr__nfet_01v8 ad=0.0693 pd=0.75 as=0.0441 ps=0.63 w=0.42 l=0.15
X7 VPWR A a_382_413# VPB sky130_fd_pr__pfet_01v8_hvt ad=0.0567 pd=0.69 as=0.0567 ps=0.69 w=0.42 l=0.15
X8 a_995_47# a_76_199# a_738_47# VNB sky130_fd_pr__nfet_01v8 ad=0.0693 pd=0.75 as=0.0619 ps=0.715 w=0.42 l=0.15
X9 a_382_413# CIN a_76_199# VPB sky130_fd_pr__pfet_01v8_hvt ad=0.0567 pd=0.69 as=0.0567 ps=0.69 w=0.42 l=0.15
X10 SUM a_995_47# VGND VNB sky130_fd_pr__nfet_01v8 ad=0.169 pd=1.82 as=0.102 ps=0.995 w=0.65 l=0.15
X11 a_208_47# A VGND VNB sky130_fd_pr__nfet_01v8 ad=0.063 pd=0.72 as=0.102 ps=0.995 w=0.42 l=0.15
X12 VGND CIN a_738_47# VNB sky130_fd_pr__nfet_01v8 ad=0.0567 pd=0.69 as=0.0567 ps=0.69 w=0.42 l=0.15
X13 a_76_199# B a_208_413# VPB sky130_fd_pr__pfet_01v8_hvt ad=0.0567 pd=0.69 as=0.063 ps=0.72 w=0.42 l=0.15
X14 a_208_413# A VPWR VPB sky130_fd_pr__pfet_01v8_hvt ad=0.063 pd=0.72 as=0.148 ps=1.35 w=0.42 l=0.15
X15 a_738_413# B VPWR VPB sky130_fd_pr__pfet_01v8_hvt ad=0.0567 pd=0.69 as=0.109 ps=1.36 w=0.42 l=0.15
X16 VGND A a_1163_47# VNB sky130_fd_pr__nfet_01v8 ad=0.102 pd=0.995 as=0.0693 ps=0.75 w=0.42 l=0.15
X17 a_738_47# B VGND VNB sky130_fd_pr__nfet_01v8 ad=0.0567 pd=0.69 as=0.109 ps=1.36 w=0.42 l=0.15
X18 a_738_47# A VGND VNB sky130_fd_pr__nfet_01v8 ad=0.0619 pd=0.715 as=0.0567 ps=0.69 w=0.42 l=0.15
X19 a_1163_413# B a_1091_413# VPB sky130_fd_pr__pfet_01v8_hvt ad=0.0693 pd=0.75 as=0.0441 ps=0.63 w=0.42 l=0.15
X20 VPWR A a_1163_413# VPB sky130_fd_pr__pfet_01v8_hvt ad=0.148 pd=1.35 as=0.0693 ps=0.75 w=0.42 l=0.15
X21 a_382_47# CIN a_76_199# VNB sky130_fd_pr__nfet_01v8 ad=0.0567 pd=0.69 as=0.0567 ps=0.69 w=0.42 l=0.15
X22 a_382_47# B VGND VNB sky130_fd_pr__nfet_01v8 ad=0.109 pd=1.36 as=0.0567 ps=0.69 w=0.42 l=0.15
X23 SUM a_995_47# VPWR VPB sky130_fd_pr__pfet_01v8_hvt ad=0.26 pd=2.52 as=0.148 ps=1.35 w=1 l=0.15
X24 a_995_47# a_76_199# a_738_413# VPB sky130_fd_pr__pfet_01v8_hvt ad=0.0693 pd=0.75 as=0.0619 ps=0.715 w=0.42 l=0.15
X25 VPWR a_76_199# COUT VPB sky130_fd_pr__pfet_01v8_hvt ad=0.148 pd=1.35 as=0.26 ps=2.52 w=1 l=0.15
X26 a_1091_413# CIN a_995_47# VPB sky130_fd_pr__pfet_01v8_hvt ad=0.0441 pd=0.63 as=0.0693 ps=0.75 w=0.42 l=0.15
X27 VGND a_76_199# COUT VNB sky130_fd_pr__nfet_01v8 ad=0.102 pd=0.995 as=0.169 ps=1.82 w=0.65 l=0.15
.ends

.subckt sky130_fd_sc_hd__xor2_1 VNB VPB VPWR VGND A X B
X0 X a_35_297# a_285_297# VPB sky130_fd_pr__pfet_01v8_hvt ad=0.3 pd=2.6 as=0.26 ps=2.52 w=1 l=0.15
X1 X B a_285_47# VNB sky130_fd_pr__nfet_01v8 ad=0.25 pd=1.42 as=0.0878 ps=0.92 w=0.65 l=0.15
X2 a_35_297# B VGND VNB sky130_fd_pr__nfet_01v8 ad=0.0878 pd=0.92 as=0.169 ps=1.82 w=0.65 l=0.15
X3 a_117_297# B a_35_297# VPB sky130_fd_pr__pfet_01v8_hvt ad=0.135 pd=1.27 as=0.26 ps=2.52 w=1 l=0.15
X4 VPWR B a_285_297# VPB sky130_fd_pr__pfet_01v8_hvt ad=0.26 pd=2.52 as=0.135 ps=1.27 w=1 l=0.15
X5 VGND A a_35_297# VNB sky130_fd_pr__nfet_01v8 ad=0.0878 pd=0.92 as=0.0878 ps=0.92 w=0.65 l=0.15
X6 VGND a_35_297# X VNB sky130_fd_pr__nfet_01v8 ad=0.208 pd=1.94 as=0.25 ps=1.42 w=0.65 l=0.15
X7 a_285_297# A VPWR VPB sky130_fd_pr__pfet_01v8_hvt ad=0.135 pd=1.27 as=0.135 ps=1.27 w=1 l=0.15
X8 VPWR A a_117_297# VPB sky130_fd_pr__pfet_01v8_hvt ad=0.135 pd=1.27 as=0.135 ps=1.27 w=1 l=0.15
X9 a_285_47# A VGND VNB sky130_fd_pr__nfet_01v8 ad=0.0878 pd=0.92 as=0.0878 ps=0.92 w=0.65 l=0.15
.ends

.subckt sky130_fd_sc_hd__clkbuf_4 VGND VPWR A X VPB VNB
X0 VPWR A a_27_47# VPB sky130_fd_pr__pfet_01v8_hvt ad=0.165 pd=1.33 as=0.265 ps=2.53 w=1 l=0.15
X1 VGND a_27_47# X VNB sky130_fd_pr__nfet_01v8 ad=0.122 pd=1.42 as=0.0588 ps=0.7 w=0.42 l=0.15
X2 VGND a_27_47# X VNB sky130_fd_pr__nfet_01v8 ad=0.0588 pd=0.7 as=0.0588 ps=0.7 w=0.42 l=0.15
X3 X a_27_47# VPWR VPB sky130_fd_pr__pfet_01v8_hvt ad=0.14 pd=1.28 as=0.14 ps=1.28 w=1 l=0.15
X4 X a_27_47# VGND VNB sky130_fd_pr__nfet_01v8 ad=0.0588 pd=0.7 as=0.0588 ps=0.7 w=0.42 l=0.15
X5 VGND A a_27_47# VNB sky130_fd_pr__nfet_01v8 ad=0.0703 pd=0.755 as=0.111 ps=1.37 w=0.42 l=0.15
X6 VPWR a_27_47# X VPB sky130_fd_pr__pfet_01v8_hvt ad=0.3 pd=2.6 as=0.14 ps=1.28 w=1 l=0.15
X7 X a_27_47# VGND VNB sky130_fd_pr__nfet_01v8 ad=0.0588 pd=0.7 as=0.0703 ps=0.755 w=0.42 l=0.15
X8 X a_27_47# VPWR VPB sky130_fd_pr__pfet_01v8_hvt ad=0.14 pd=1.28 as=0.165 ps=1.33 w=1 l=0.15
X9 VPWR a_27_47# X VPB sky130_fd_pr__pfet_01v8_hvt ad=0.14 pd=1.28 as=0.14 ps=1.28 w=1 l=0.15
.ends

.subckt sky130_fd_sc_hd__lpflow_isobufsrc_1 VPB VNB VGND VPWR A SLEEP X
X0 X a_74_47# a_265_297# VPB sky130_fd_pr__pfet_01v8_hvt ad=0.26 pd=2.52 as=0.105 ps=1.21 w=1 l=0.15
X1 VPWR A a_74_47# VPB sky130_fd_pr__pfet_01v8_hvt ad=0.157 pd=1.39 as=0.109 ps=1.36 w=0.42 l=0.15
X2 a_265_297# SLEEP VPWR VPB sky130_fd_pr__pfet_01v8_hvt ad=0.105 pd=1.21 as=0.157 ps=1.39 w=1 l=0.15
X3 X SLEEP VGND VNB sky130_fd_pr__nfet_01v8 ad=0.0878 pd=0.92 as=0.1 ps=0.985 w=0.65 l=0.15
X4 VGND A a_74_47# VNB sky130_fd_pr__nfet_01v8 ad=0.1 pd=0.985 as=0.109 ps=1.36 w=0.42 l=0.15
X5 VGND a_74_47# X VNB sky130_fd_pr__nfet_01v8 ad=0.169 pd=1.82 as=0.0878 ps=0.92 w=0.65 l=0.15
.ends

.subckt sky130_fd_sc_hd__mux2i_1 VPB VNB VGND VPWR A0 Y A1 S
X0 a_27_297# S VPWR VPB sky130_fd_pr__pfet_01v8_hvt ad=0.26 pd=2.52 as=0.3 ps=1.6 w=1 l=0.15
X1 VGND S a_283_205# VNB sky130_fd_pr__nfet_01v8 ad=0.169 pd=1.82 as=0.169 ps=1.82 w=0.65 l=0.15
X2 a_204_297# A1 Y VPB sky130_fd_pr__pfet_01v8_hvt ad=0.198 pd=1.39 as=0.153 ps=1.3 w=1 l=0.15
X3 a_193_47# A1 Y VNB sky130_fd_pr__nfet_01v8 ad=0.182 pd=1.86 as=0.0878 ps=0.92 w=0.65 l=0.15
X4 Y A0 a_27_297# VPB sky130_fd_pr__pfet_01v8_hvt ad=0.153 pd=1.3 as=0.28 ps=2.56 w=1 l=0.15
X5 VPWR a_283_205# a_204_297# VPB sky130_fd_pr__pfet_01v8_hvt ad=0.3 pd=1.6 as=0.198 ps=1.39 w=1 l=0.15
X6 VPWR S a_283_205# VPB sky130_fd_pr__pfet_01v8_hvt ad=0.26 pd=2.52 as=0.29 ps=2.58 w=1 l=0.15
X7 VGND a_283_205# a_27_47# VNB sky130_fd_pr__nfet_01v8 ad=0.0878 pd=0.92 as=0.169 ps=1.82 w=0.65 l=0.15
X8 a_193_47# S VGND VNB sky130_fd_pr__nfet_01v8 ad=0.169 pd=1.82 as=0.0878 ps=0.92 w=0.65 l=0.15
X9 Y A0 a_27_47# VNB sky130_fd_pr__nfet_01v8 ad=0.0878 pd=0.92 as=0.169 ps=1.82 w=0.65 l=0.15
.ends

.subckt sky130_fd_sc_hd__sdfxtp_1 VPWR VGND Q CLK D SCE SCD VPB VNB
X0 a_640_369# a_299_47# a_556_369# VPB sky130_fd_pr__pfet_01v8_hvt ad=0.102 pd=0.96 as=0.0864 ps=0.91 w=0.64 l=0.15
X1 a_933_413# a_193_47# a_556_369# VPB sky130_fd_pr__pfet_01v8_hvt ad=0.0662 pd=0.735 as=0.128 ps=1.45 w=0.42 l=0.15
X2 a_556_369# D a_467_369# VPB sky130_fd_pr__pfet_01v8_hvt ad=0.0864 pd=0.91 as=0.0944 ps=0.935 w=0.64 l=0.15
X3 a_1030_47# a_193_47# a_933_413# VNB sky130_fd_pr__special_nfet_01v8 ad=0.0687 pd=0.76 as=0.0594 ps=0.69 w=0.36 l=0.15
X4 a_1092_183# a_933_413# VGND VNB sky130_fd_pr__nfet_01v8 ad=0.0989 pd=0.995 as=0.149 ps=1.22 w=0.64 l=0.15
X5 VPWR a_1349_413# a_1520_315# VPB sky130_fd_pr__pfet_01v8_hvt ad=0.153 pd=1.3 as=0.26 ps=2.52 w=1 l=0.15
X6 VPWR SCE a_299_47# VPB sky130_fd_pr__pfet_01v8_hvt ad=0.088 pd=0.915 as=0.166 ps=1.8 w=0.64 l=0.15
X7 Q a_1520_315# VPWR VPB sky130_fd_pr__pfet_01v8_hvt ad=0.26 pd=2.52 as=0.153 ps=1.3 w=1 l=0.15
X8 VPWR CLK a_27_47# VPB sky130_fd_pr__pfet_01v8_hvt ad=0.0864 pd=0.91 as=0.166 ps=1.8 w=0.64 l=0.15
X9 a_467_369# SCE VPWR VPB sky130_fd_pr__pfet_01v8_hvt ad=0.0944 pd=0.935 as=0.088 ps=0.915 w=0.64 l=0.15
X10 a_1026_413# a_27_47# a_933_413# VPB sky130_fd_pr__pfet_01v8_hvt ad=0.0693 pd=0.75 as=0.0662 ps=0.735 w=0.42 l=0.15
X11 a_657_47# SCE a_556_369# VNB sky130_fd_pr__nfet_01v8 ad=0.0483 pd=0.65 as=0.0693 ps=0.75 w=0.42 l=0.15
X12 VPWR a_1520_315# a_1433_413# VPB sky130_fd_pr__pfet_01v8_hvt ad=0.157 pd=1.59 as=0.0913 ps=0.855 w=0.42 l=0.15
X13 Q a_1520_315# VGND VNB sky130_fd_pr__nfet_01v8 ad=0.169 pd=1.82 as=0.0991 ps=0.955 w=0.65 l=0.15
X14 a_933_413# a_27_47# a_556_369# VNB sky130_fd_pr__special_nfet_01v8 ad=0.0594 pd=0.69 as=0.099 ps=1.27 w=0.36 l=0.15
X15 VPWR a_1092_183# a_1026_413# VPB sky130_fd_pr__pfet_01v8_hvt ad=0.179 pd=1.26 as=0.0693 ps=0.75 w=0.42 l=0.15
X16 VGND a_1092_183# a_1030_47# VNB sky130_fd_pr__nfet_01v8 ad=0.149 pd=1.22 as=0.0687 ps=0.76 w=0.42 l=0.15
X17 VGND a_1520_315# a_1478_47# VNB sky130_fd_pr__nfet_01v8 ad=0.109 pd=1.36 as=0.066 ps=0.745 w=0.42 l=0.15
X18 a_193_47# a_27_47# VGND VNB sky130_fd_pr__nfet_01v8 ad=0.109 pd=1.36 as=0.0567 ps=0.69 w=0.42 l=0.15
X19 a_483_47# a_299_47# VGND VNB sky130_fd_pr__nfet_01v8 ad=0.0504 pd=0.66 as=0.0714 ps=0.76 w=0.42 l=0.15
X20 a_1478_47# a_27_47# a_1349_413# VNB sky130_fd_pr__special_nfet_01v8 ad=0.066 pd=0.745 as=0.0657 ps=0.725 w=0.36 l=0.15
X21 VPWR SCD a_640_369# VPB sky130_fd_pr__pfet_01v8_hvt ad=0.173 pd=1.82 as=0.102 ps=0.96 w=0.64 l=0.15
X22 a_1433_413# a_193_47# a_1349_413# VPB sky130_fd_pr__pfet_01v8_hvt ad=0.0913 pd=0.855 as=0.0567 ps=0.69 w=0.42 l=0.15
X23 VGND SCE a_299_47# VNB sky130_fd_pr__nfet_01v8 ad=0.0714 pd=0.76 as=0.118 ps=1.4 w=0.42 l=0.15
X24 a_1092_183# a_933_413# VPWR VPB sky130_fd_pr__pfet_01v8_hvt ad=0.109 pd=1.08 as=0.179 ps=1.26 w=0.75 l=0.15
X25 a_1349_413# a_27_47# a_1092_183# VPB sky130_fd_pr__pfet_01v8_hvt ad=0.0567 pd=0.69 as=0.109 ps=1.08 w=0.42 l=0.15
X26 VGND a_1349_413# a_1520_315# VNB sky130_fd_pr__nfet_01v8 ad=0.0991 pd=0.955 as=0.169 ps=1.82 w=0.65 l=0.15
X27 VGND SCD a_657_47# VNB sky130_fd_pr__nfet_01v8 ad=0.13 pd=1.46 as=0.0483 ps=0.65 w=0.42 l=0.15
X28 a_193_47# a_27_47# VPWR VPB sky130_fd_pr__pfet_01v8_hvt ad=0.166 pd=1.8 as=0.0864 ps=0.91 w=0.64 l=0.15
X29 a_1349_413# a_193_47# a_1092_183# VNB sky130_fd_pr__special_nfet_01v8 ad=0.0657 pd=0.725 as=0.0989 ps=0.995 w=0.36 l=0.15
X30 VGND CLK a_27_47# VNB sky130_fd_pr__nfet_01v8 ad=0.0567 pd=0.69 as=0.109 ps=1.36 w=0.42 l=0.15
X31 a_556_369# D a_483_47# VNB sky130_fd_pr__nfet_01v8 ad=0.0693 pd=0.75 as=0.0504 ps=0.66 w=0.42 l=0.15
.ends

.subckt sky130_fd_sc_hd__fa_2 VPB VNB VGND VPWR A COUT B CIN SUM
X0 a_1171_369# CIN a_1086_47# VPB sky130_fd_pr__pfet_01v8_hvt ad=0.104 pd=0.965 as=0.088 ps=0.915 w=0.64 l=0.15
X1 VGND CIN a_829_47# VNB sky130_fd_pr__nfet_01v8 ad=0.0567 pd=0.69 as=0.0567 ps=0.69 w=0.42 l=0.15
X2 VGND a_1086_47# SUM VNB sky130_fd_pr__nfet_01v8 ad=0.169 pd=1.82 as=0.127 ps=1.04 w=0.65 l=0.15
X3 COUT a_80_21# VPWR VPB sky130_fd_pr__pfet_01v8_hvt ad=0.135 pd=1.27 as=0.26 ps=2.52 w=1 l=0.15
X4 a_829_369# A VPWR VPB sky130_fd_pr__pfet_01v8_hvt ad=0.0944 pd=0.935 as=0.0864 ps=0.91 w=0.64 l=0.15
X5 VPWR CIN a_829_369# VPB sky130_fd_pr__pfet_01v8_hvt ad=0.0864 pd=0.91 as=0.0864 ps=0.91 w=0.64 l=0.15
X6 a_473_371# B VPWR VPB sky130_fd_pr__pfet_01v8_hvt ad=0.164 pd=1.78 as=0.0851 ps=0.9 w=0.63 l=0.15
X7 a_294_47# A VGND VNB sky130_fd_pr__nfet_01v8 ad=0.0683 pd=0.745 as=0.103 ps=1 w=0.42 l=0.15
X8 VPWR A a_473_371# VPB sky130_fd_pr__pfet_01v8_hvt ad=0.0851 pd=0.9 as=0.0851 ps=0.9 w=0.63 l=0.15
X9 a_829_369# B VPWR VPB sky130_fd_pr__pfet_01v8_hvt ad=0.0864 pd=0.91 as=0.166 ps=1.8 w=0.64 l=0.15
X10 a_829_47# B VGND VNB sky130_fd_pr__nfet_01v8 ad=0.0567 pd=0.69 as=0.109 ps=1.36 w=0.42 l=0.15
X11 a_829_47# A VGND VNB sky130_fd_pr__nfet_01v8 ad=0.0619 pd=0.715 as=0.0567 ps=0.69 w=0.42 l=0.15
X12 a_473_371# CIN a_80_21# VPB sky130_fd_pr__pfet_01v8_hvt ad=0.0851 pd=0.9 as=0.102 ps=0.955 w=0.63 l=0.15
X13 a_473_47# CIN a_80_21# VNB sky130_fd_pr__nfet_01v8 ad=0.0567 pd=0.69 as=0.0567 ps=0.69 w=0.42 l=0.15
X14 a_473_47# B VGND VNB sky130_fd_pr__nfet_01v8 ad=0.109 pd=1.36 as=0.0567 ps=0.69 w=0.42 l=0.15
X15 VPWR a_1086_47# SUM VPB sky130_fd_pr__pfet_01v8_hvt ad=0.26 pd=2.52 as=0.135 ps=1.27 w=1 l=0.15
X16 VGND a_80_21# COUT VNB sky130_fd_pr__nfet_01v8 ad=0.103 pd=1 as=0.0878 ps=0.92 w=0.65 l=0.15
X17 COUT a_80_21# VGND VNB sky130_fd_pr__nfet_01v8 ad=0.0878 pd=0.92 as=0.169 ps=1.82 w=0.65 l=0.15
X18 SUM a_1086_47# VPWR VPB sky130_fd_pr__pfet_01v8_hvt ad=0.135 pd=1.27 as=0.149 ps=1.33 w=1 l=0.15
X19 a_80_21# B a_289_371# VPB sky130_fd_pr__pfet_01v8_hvt ad=0.102 pd=0.955 as=0.0929 ps=0.925 w=0.63 l=0.15
X20 a_80_21# B a_294_47# VNB sky130_fd_pr__nfet_01v8 ad=0.0567 pd=0.69 as=0.0683 ps=0.745 w=0.42 l=0.15
X21 VGND A a_473_47# VNB sky130_fd_pr__nfet_01v8 ad=0.0567 pd=0.69 as=0.0567 ps=0.69 w=0.42 l=0.15
X22 SUM a_1086_47# VGND VNB sky130_fd_pr__nfet_01v8 ad=0.127 pd=1.04 as=0.102 ps=0.995 w=0.65 l=0.15
X23 VPWR a_80_21# COUT VPB sky130_fd_pr__pfet_01v8_hvt ad=0.149 pd=1.33 as=0.135 ps=1.27 w=1 l=0.15
X24 a_289_371# A VPWR VPB sky130_fd_pr__pfet_01v8_hvt ad=0.0929 pd=0.925 as=0.149 ps=1.33 w=0.63 l=0.15
X25 a_1194_47# CIN a_1086_47# VNB sky130_fd_pr__nfet_01v8 ad=0.0441 pd=0.63 as=0.0819 ps=0.81 w=0.42 l=0.15
X26 a_1086_47# a_80_21# a_829_47# VNB sky130_fd_pr__nfet_01v8 ad=0.0819 pd=0.81 as=0.0619 ps=0.715 w=0.42 l=0.15
X27 VGND A a_1266_47# VNB sky130_fd_pr__nfet_01v8 ad=0.102 pd=0.995 as=0.0693 ps=0.75 w=0.42 l=0.15
X28 a_1266_371# B a_1171_369# VPB sky130_fd_pr__pfet_01v8_hvt ad=0.123 pd=1.02 as=0.104 ps=0.965 w=0.63 l=0.15
X29 VPWR A a_1266_371# VPB sky130_fd_pr__pfet_01v8_hvt ad=0.149 pd=1.33 as=0.123 ps=1.02 w=0.63 l=0.15
X30 a_1266_47# B a_1194_47# VNB sky130_fd_pr__nfet_01v8 ad=0.0693 pd=0.75 as=0.0441 ps=0.63 w=0.42 l=0.15
X31 a_1086_47# a_80_21# a_829_369# VPB sky130_fd_pr__pfet_01v8_hvt ad=0.088 pd=0.915 as=0.0944 ps=0.935 w=0.64 l=0.15
.ends

.subckt sky130_fd_sc_hd__dlygate4sd3_1 X A VPB VNB VGND VPWR
X0 VPWR A a_49_47# VPB sky130_fd_pr__pfet_01v8_hvt ad=0.0567 pd=0.69 as=0.109 ps=1.36 w=0.42 l=0.15
X1 VGND a_285_47# a_391_47# VNB sky130_fd_pr__nfet_01v8 ad=0.097 pd=0.975 as=0.109 ps=1.36 w=0.42 l=0.5
X2 X a_391_47# VPWR VPB sky130_fd_pr__pfet_01v8_hvt ad=0.26 pd=2.52 as=0.141 ps=1.33 w=1 l=0.15
X3 VGND A a_49_47# VNB sky130_fd_pr__nfet_01v8 ad=0.0567 pd=0.69 as=0.109 ps=1.36 w=0.42 l=0.15
X4 VPWR a_285_47# a_391_47# VPB sky130_fd_pr__pfet_01v8_hvt ad=0.141 pd=1.33 as=0.109 ps=1.36 w=0.42 l=0.5
X5 a_285_47# a_49_47# VGND VNB sky130_fd_pr__nfet_01v8 ad=0.109 pd=1.36 as=0.0567 ps=0.69 w=0.42 l=0.5
X6 a_285_47# a_49_47# VPWR VPB sky130_fd_pr__pfet_01v8_hvt ad=0.109 pd=1.36 as=0.0567 ps=0.69 w=0.42 l=0.5
X7 X a_391_47# VGND VNB sky130_fd_pr__nfet_01v8 ad=0.169 pd=1.82 as=0.097 ps=0.975 w=0.65 l=0.15
.ends

.subckt sky130_fd_sc_hd__xnor2_1 VGND VPWR B Y A VPB VNB
X0 a_377_297# A VPWR VPB sky130_fd_pr__pfet_01v8_hvt ad=0.105 pd=1.21 as=0.365 ps=1.73 w=1 l=0.15
X1 a_47_47# B VPWR VPB sky130_fd_pr__pfet_01v8_hvt ad=0.135 pd=1.27 as=0.3 ps=2.6 w=1 l=0.15
X2 a_129_47# B a_47_47# VNB sky130_fd_pr__nfet_01v8 ad=0.0683 pd=0.86 as=0.169 ps=1.82 w=0.65 l=0.15
X3 a_285_47# B VGND VNB sky130_fd_pr__nfet_01v8 ad=0.0878 pd=0.92 as=0.169 ps=1.82 w=0.65 l=0.15
X4 Y a_47_47# a_285_47# VNB sky130_fd_pr__nfet_01v8 ad=0.195 pd=1.9 as=0.0878 ps=0.92 w=0.65 l=0.15
X5 VGND A a_129_47# VNB sky130_fd_pr__nfet_01v8 ad=0.0878 pd=0.92 as=0.0683 ps=0.86 w=0.65 l=0.15
X6 VPWR A a_47_47# VPB sky130_fd_pr__pfet_01v8_hvt ad=0.365 pd=1.73 as=0.135 ps=1.27 w=1 l=0.15
X7 VPWR a_47_47# Y VPB sky130_fd_pr__pfet_01v8_hvt ad=0.36 pd=2.72 as=0.165 ps=1.33 w=1 l=0.15
X8 Y B a_377_297# VPB sky130_fd_pr__pfet_01v8_hvt ad=0.165 pd=1.33 as=0.105 ps=1.21 w=1 l=0.15
X9 a_285_47# A VGND VNB sky130_fd_pr__nfet_01v8 ad=0.169 pd=1.82 as=0.0878 ps=0.92 w=0.65 l=0.15
.ends

.subckt sky130_fd_sc_hd__xnor2_2 VGND VPWR Y A B VPB VNB
X0 a_27_297# B VPWR VPB sky130_fd_pr__pfet_01v8_hvt ad=0.135 pd=1.27 as=0.135 ps=1.27 w=1 l=0.15
X1 a_560_47# A VGND VNB sky130_fd_pr__nfet_01v8 ad=0.0878 pd=0.92 as=0.182 ps=1.86 w=0.65 l=0.15
X2 VGND B a_560_47# VNB sky130_fd_pr__nfet_01v8 ad=0.169 pd=1.82 as=0.0991 ps=0.955 w=0.65 l=0.15
X3 Y B a_474_297# VPB sky130_fd_pr__pfet_01v8_hvt ad=0.153 pd=1.3 as=0.135 ps=1.27 w=1 l=0.15
X4 VGND A a_27_47# VNB sky130_fd_pr__nfet_01v8 ad=0.0878 pd=0.92 as=0.0878 ps=0.92 w=0.65 l=0.15
X5 Y a_27_297# a_560_47# VNB sky130_fd_pr__nfet_01v8 ad=0.169 pd=1.82 as=0.0878 ps=0.92 w=0.65 l=0.15
X6 a_474_297# B Y VPB sky130_fd_pr__pfet_01v8_hvt ad=0.26 pd=2.52 as=0.153 ps=1.3 w=1 l=0.15
X7 VGND A a_560_47# VNB sky130_fd_pr__nfet_01v8 ad=0.0878 pd=0.92 as=0.0878 ps=0.92 w=0.65 l=0.15
X8 a_27_47# B a_27_297# VNB sky130_fd_pr__nfet_01v8 ad=0.0878 pd=0.92 as=0.0878 ps=0.92 w=0.65 l=0.15
X9 a_27_297# B a_27_47# VNB sky130_fd_pr__nfet_01v8 ad=0.0878 pd=0.92 as=0.179 ps=1.85 w=0.65 l=0.15
X10 a_27_47# A VGND VNB sky130_fd_pr__nfet_01v8 ad=0.182 pd=1.86 as=0.0878 ps=0.92 w=0.65 l=0.15
X11 VPWR B a_27_297# VPB sky130_fd_pr__pfet_01v8_hvt ad=0.135 pd=1.27 as=0.275 ps=2.55 w=1 l=0.15
X12 a_474_297# A VPWR VPB sky130_fd_pr__pfet_01v8_hvt ad=0.135 pd=1.27 as=0.135 ps=1.27 w=1 l=0.15
X13 a_560_47# a_27_297# Y VNB sky130_fd_pr__nfet_01v8 ad=0.0878 pd=0.92 as=0.169 ps=1.82 w=0.65 l=0.15
X14 VPWR A a_474_297# VPB sky130_fd_pr__pfet_01v8_hvt ad=0.135 pd=1.27 as=0.28 ps=2.56 w=1 l=0.15
X15 Y a_27_297# VPWR VPB sky130_fd_pr__pfet_01v8_hvt ad=0.135 pd=1.27 as=0.26 ps=2.52 w=1 l=0.15
X16 VPWR a_27_297# Y VPB sky130_fd_pr__pfet_01v8_hvt ad=0.28 pd=2.56 as=0.135 ps=1.27 w=1 l=0.15
X17 a_560_47# B VGND VNB sky130_fd_pr__nfet_01v8 ad=0.0991 pd=0.955 as=0.0878 ps=0.92 w=0.65 l=0.15
X18 a_27_297# A VPWR VPB sky130_fd_pr__pfet_01v8_hvt ad=0.28 pd=2.56 as=0.135 ps=1.27 w=1 l=0.15
X19 VPWR A a_27_297# VPB sky130_fd_pr__pfet_01v8_hvt ad=0.135 pd=1.27 as=0.135 ps=1.27 w=1 l=0.15
.ends

.subckt sky130_fd_sc_hd__nand4_2 VNB VPB VGND VPWR D C Y B A
X0 VPWR C Y VPB sky130_fd_pr__pfet_01v8_hvt ad=0.215 pd=1.43 as=0.135 ps=1.27 w=1 l=0.15
X1 a_471_47# B a_277_47# VNB sky130_fd_pr__nfet_01v8 ad=0.0878 pd=0.92 as=0.0878 ps=0.92 w=0.65 l=0.15
X2 Y C VPWR VPB sky130_fd_pr__pfet_01v8_hvt ad=0.135 pd=1.27 as=0.135 ps=1.27 w=1 l=0.15
X3 VPWR D Y VPB sky130_fd_pr__pfet_01v8_hvt ad=0.135 pd=1.27 as=0.135 ps=1.27 w=1 l=0.15
X4 VPWR A Y VPB sky130_fd_pr__pfet_01v8_hvt ad=0.42 pd=2.84 as=0.135 ps=1.27 w=1 l=0.15
X5 a_27_47# D VGND VNB sky130_fd_pr__nfet_01v8 ad=0.0878 pd=0.92 as=0.0878 ps=0.92 w=0.65 l=0.15
X6 a_27_47# C a_277_47# VNB sky130_fd_pr__nfet_01v8 ad=0.182 pd=1.86 as=0.0878 ps=0.92 w=0.65 l=0.15
X7 Y A VPWR VPB sky130_fd_pr__pfet_01v8_hvt ad=0.135 pd=1.27 as=0.335 ps=1.67 w=1 l=0.15
X8 a_277_47# B a_471_47# VNB sky130_fd_pr__nfet_01v8 ad=0.0878 pd=0.92 as=0.182 ps=1.86 w=0.65 l=0.15
X9 VPWR B Y VPB sky130_fd_pr__pfet_01v8_hvt ad=0.335 pd=1.67 as=0.135 ps=1.27 w=1 l=0.15
X10 Y A a_471_47# VNB sky130_fd_pr__nfet_01v8 ad=0.0878 pd=0.92 as=0.0878 ps=0.92 w=0.65 l=0.15
X11 a_277_47# C a_27_47# VNB sky130_fd_pr__nfet_01v8 ad=0.0878 pd=0.92 as=0.0878 ps=0.92 w=0.65 l=0.15
X12 Y B VPWR VPB sky130_fd_pr__pfet_01v8_hvt ad=0.135 pd=1.27 as=0.215 ps=1.43 w=1 l=0.15
X13 a_471_47# A Y VNB sky130_fd_pr__nfet_01v8 ad=0.234 pd=2.02 as=0.0878 ps=0.92 w=0.65 l=0.15
X14 Y D VPWR VPB sky130_fd_pr__pfet_01v8_hvt ad=0.135 pd=1.27 as=0.26 ps=2.52 w=1 l=0.15
X15 VGND D a_27_47# VNB sky130_fd_pr__nfet_01v8 ad=0.0878 pd=0.92 as=0.169 ps=1.82 w=0.65 l=0.15
.ends

.subckt sky130_fd_sc_hd__a22o_1 VPWR VGND VPB VNB B1 A1 A2 X B2
X0 VPWR A2 a_109_297# VPB sky130_fd_pr__pfet_01v8_hvt ad=0.155 pd=1.31 as=0.16 ps=1.32 w=1 l=0.15
X1 a_27_297# B1 a_109_47# VNB sky130_fd_pr__nfet_01v8 ad=0.169 pd=1.82 as=0.0747 ps=0.88 w=0.65 l=0.15
X2 VGND A2 a_373_47# VNB sky130_fd_pr__nfet_01v8 ad=0.101 pd=0.96 as=0.114 ps=1 w=0.65 l=0.15
X3 X a_27_297# VPWR VPB sky130_fd_pr__pfet_01v8_hvt ad=0.26 pd=2.52 as=0.155 ps=1.31 w=1 l=0.15
X4 a_27_297# B1 a_109_297# VPB sky130_fd_pr__pfet_01v8_hvt ad=0.253 pd=2.52 as=0.135 ps=1.27 w=1 l=0.15
X5 a_109_297# A1 VPWR VPB sky130_fd_pr__pfet_01v8_hvt ad=0.16 pd=1.32 as=0.253 ps=2.52 w=1 l=0.15
X6 a_373_47# A1 a_27_297# VNB sky130_fd_pr__nfet_01v8 ad=0.114 pd=1 as=0.169 ps=1.82 w=0.65 l=0.15
X7 X a_27_297# VGND VNB sky130_fd_pr__nfet_01v8 ad=0.169 pd=1.82 as=0.101 ps=0.96 w=0.65 l=0.15
X8 a_109_297# B2 a_27_297# VPB sky130_fd_pr__pfet_01v8_hvt ad=0.135 pd=1.27 as=0.26 ps=2.52 w=1 l=0.15
X9 a_109_47# B2 VGND VNB sky130_fd_pr__nfet_01v8 ad=0.0747 pd=0.88 as=0.169 ps=1.82 w=0.65 l=0.15
.ends

.subckt sky130_fd_sc_hd__nor2_1 VPB VNB VGND VPWR A B Y
X0 VPWR A a_109_297# VPB sky130_fd_pr__pfet_01v8_hvt ad=0.26 pd=2.52 as=0.105 ps=1.21 w=1 l=0.15
X1 VGND A Y VNB sky130_fd_pr__nfet_01v8 ad=0.169 pd=1.82 as=0.0878 ps=0.92 w=0.65 l=0.15
X2 a_109_297# B Y VPB sky130_fd_pr__pfet_01v8_hvt ad=0.105 pd=1.21 as=0.26 ps=2.52 w=1 l=0.15
X3 Y B VGND VNB sky130_fd_pr__nfet_01v8 ad=0.0878 pd=0.92 as=0.169 ps=1.82 w=0.65 l=0.15
.ends

.subckt sky130_fd_sc_hd__clkdlybuf4s25_1 VNB VPB VPWR VGND A X
X0 a_244_47# a_27_47# VPWR VPB sky130_fd_pr__pfet_01v8_hvt ad=0.217 pd=2.17 as=0.193 ps=1.41 w=0.82 l=0.25
X1 VPWR a_244_47# a_355_47# VPB sky130_fd_pr__pfet_01v8_hvt ad=0.273 pd=1.61 as=0.217 ps=2.17 w=0.82 l=0.25
X2 X a_355_47# VPWR VPB sky130_fd_pr__pfet_01v8_hvt ad=0.495 pd=2.99 as=0.273 ps=1.61 w=1 l=0.15
X3 VPWR A a_27_47# VPB sky130_fd_pr__pfet_01v8_hvt ad=0.193 pd=1.41 as=0.27 ps=2.54 w=1 l=0.15
X4 VGND A a_27_47# VNB sky130_fd_pr__nfet_01v8 ad=0.123 pd=1.07 as=0.113 ps=1.38 w=0.42 l=0.15
X5 VGND a_244_47# a_355_47# VNB sky130_fd_pr__nfet_01v8 ad=0.186 pd=1.26 as=0.172 ps=1.83 w=0.65 l=0.25
X6 X a_355_47# VGND VNB sky130_fd_pr__nfet_01v8 ad=0.208 pd=1.83 as=0.186 ps=1.26 w=0.42 l=0.15
X7 a_244_47# a_27_47# VGND VNB sky130_fd_pr__nfet_01v8 ad=0.172 pd=1.83 as=0.123 ps=1.07 w=0.65 l=0.25
.ends

.subckt sky130_fd_sc_hd__maj3_1 VPB VNB VGND VPWR X C A B
X0 X a_27_47# VGND VNB sky130_fd_pr__nfet_01v8 ad=0.237 pd=2.03 as=0.147 ps=1.22 w=0.65 l=0.15
X1 X a_27_47# VPWR VPB sky130_fd_pr__pfet_01v8_hvt ad=0.365 pd=2.73 as=0.249 ps=1.57 w=1 l=0.15
X2 a_109_341# C a_27_47# VPB sky130_fd_pr__pfet_01v8_hvt ad=0.0441 pd=0.63 as=0.109 ps=1.36 w=0.42 l=0.15
X3 a_27_47# B a_265_341# VPB sky130_fd_pr__pfet_01v8_hvt ad=0.0567 pd=0.69 as=0.0441 ps=0.63 w=0.42 l=0.15
X4 VGND A a_109_47# VNB sky130_fd_pr__nfet_01v8 ad=0.0567 pd=0.69 as=0.0441 ps=0.63 w=0.42 l=0.15
X5 a_265_341# A VPWR VPB sky130_fd_pr__pfet_01v8_hvt ad=0.0441 pd=0.63 as=0.0567 ps=0.69 w=0.42 l=0.15
X6 VPWR A a_109_341# VPB sky130_fd_pr__pfet_01v8_hvt ad=0.0567 pd=0.69 as=0.0441 ps=0.63 w=0.42 l=0.15
X7 a_421_47# B a_27_47# VNB sky130_fd_pr__nfet_01v8 ad=0.0441 pd=0.63 as=0.0567 ps=0.69 w=0.42 l=0.15
X8 a_265_47# A VGND VNB sky130_fd_pr__nfet_01v8 ad=0.0441 pd=0.63 as=0.0567 ps=0.69 w=0.42 l=0.15
X9 VGND C a_421_47# VNB sky130_fd_pr__nfet_01v8 ad=0.147 pd=1.22 as=0.0441 ps=0.63 w=0.42 l=0.15
X10 a_27_47# B a_265_47# VNB sky130_fd_pr__nfet_01v8 ad=0.0567 pd=0.69 as=0.0441 ps=0.63 w=0.42 l=0.15
X11 VPWR C a_421_341# VPB sky130_fd_pr__pfet_01v8_hvt ad=0.249 pd=1.57 as=0.0441 ps=0.63 w=0.42 l=0.15
X12 a_421_341# B a_27_47# VPB sky130_fd_pr__pfet_01v8_hvt ad=0.0441 pd=0.63 as=0.0567 ps=0.69 w=0.42 l=0.15
X13 a_109_47# C a_27_47# VNB sky130_fd_pr__nfet_01v8 ad=0.0441 pd=0.63 as=0.109 ps=1.36 w=0.42 l=0.15
.ends

.subckt sky130_fd_sc_hd__or4b_1 VPWR VGND VPB VNB B C A X D_N
X0 X a_215_297# VPWR VPB sky130_fd_pr__pfet_01v8_hvt ad=0.275 pd=2.55 as=0.148 ps=1.34 w=1 l=0.15
X1 a_109_53# D_N VGND VNB sky130_fd_pr__nfet_01v8 ad=0.109 pd=1.36 as=0.109 ps=1.36 w=0.42 l=0.15
X2 a_215_297# a_109_53# VGND VNB sky130_fd_pr__nfet_01v8 ad=0.064 pd=0.725 as=0.109 ps=1.36 w=0.42 l=0.15
X3 X a_215_297# VGND VNB sky130_fd_pr__nfet_01v8 ad=0.179 pd=1.85 as=0.102 ps=0.99 w=0.65 l=0.15
X4 a_392_297# C a_297_297# VPB sky130_fd_pr__pfet_01v8_hvt ad=0.0452 pd=0.635 as=0.0683 ps=0.745 w=0.42 l=0.15
X5 a_465_297# B a_392_297# VPB sky130_fd_pr__pfet_01v8_hvt ad=0.064 pd=0.725 as=0.0452 ps=0.635 w=0.42 l=0.15
X6 a_215_297# B VGND VNB sky130_fd_pr__nfet_01v8 ad=0.0567 pd=0.69 as=0.0567 ps=0.69 w=0.42 l=0.15
X7 VPWR A a_465_297# VPB sky130_fd_pr__pfet_01v8_hvt ad=0.148 pd=1.34 as=0.064 ps=0.725 w=0.42 l=0.15
X8 a_297_297# a_109_53# a_215_297# VPB sky130_fd_pr__pfet_01v8_hvt ad=0.0683 pd=0.745 as=0.109 ps=1.36 w=0.42 l=0.15
X9 a_109_53# D_N VPWR VPB sky130_fd_pr__pfet_01v8_hvt ad=0.109 pd=1.36 as=0.109 ps=1.36 w=0.42 l=0.15
X10 VGND C a_215_297# VNB sky130_fd_pr__nfet_01v8 ad=0.0567 pd=0.69 as=0.064 ps=0.725 w=0.42 l=0.15
X11 VGND A a_215_297# VNB sky130_fd_pr__nfet_01v8 ad=0.102 pd=0.99 as=0.0567 ps=0.69 w=0.42 l=0.15
.ends

.subckt sky130_fd_sc_hd__nor3_1 VPB VNB VGND VPWR C B A Y
X0 VPWR A a_193_297# VPB sky130_fd_pr__pfet_01v8_hvt ad=0.26 pd=2.52 as=0.135 ps=1.27 w=1 l=0.15
X1 a_193_297# B a_109_297# VPB sky130_fd_pr__pfet_01v8_hvt ad=0.135 pd=1.27 as=0.135 ps=1.27 w=1 l=0.15
X2 Y B VGND VNB sky130_fd_pr__nfet_01v8 ad=0.0878 pd=0.92 as=0.0878 ps=0.92 w=0.65 l=0.15
X3 VGND A Y VNB sky130_fd_pr__nfet_01v8 ad=0.169 pd=1.82 as=0.0878 ps=0.92 w=0.65 l=0.15
X4 a_109_297# C Y VPB sky130_fd_pr__pfet_01v8_hvt ad=0.135 pd=1.27 as=0.26 ps=2.52 w=1 l=0.15
X5 VGND C Y VNB sky130_fd_pr__nfet_01v8 ad=0.0878 pd=0.92 as=0.169 ps=1.82 w=0.65 l=0.15
.ends

.subckt sky130_fd_sc_hd__dlclkp_1 VGND VPWR GCLK GATE CLK VPB VNB
X0 a_381_369# GATE VPWR VPB sky130_fd_pr__pfet_01v8_hvt ad=0.0957 pd=0.965 as=0.166 ps=1.8 w=0.64 l=0.15
X1 a_476_413# a_193_47# a_381_369# VPB sky130_fd_pr__pfet_01v8_hvt ad=0.0987 pd=0.89 as=0.0957 ps=0.965 w=0.42 l=0.15
X2 a_957_369# a_642_307# VPWR VPB sky130_fd_pr__pfet_01v8_hvt ad=0.203 pd=1.27 as=0.149 ps=1.33 w=0.64 l=0.15
X3 VPWR CLK a_27_47# VPB sky130_fd_pr__pfet_01v8_hvt ad=0.0864 pd=0.91 as=0.166 ps=1.8 w=0.64 l=0.15
X4 a_1042_47# a_642_307# a_957_369# VNB sky130_fd_pr__nfet_01v8 ad=0.0441 pd=0.63 as=0.109 ps=1.36 w=0.42 l=0.15
X5 GCLK a_957_369# VPWR VPB sky130_fd_pr__pfet_01v8_hvt ad=0.26 pd=2.52 as=0.149 ps=1.33 w=1 l=0.15
X6 VGND CLK a_1042_47# VNB sky130_fd_pr__nfet_01v8 ad=0.097 pd=0.975 as=0.0441 ps=0.63 w=0.42 l=0.15
X7 a_193_47# a_27_47# VGND VNB sky130_fd_pr__nfet_01v8 ad=0.109 pd=1.36 as=0.0567 ps=0.69 w=0.42 l=0.15
X8 a_651_47# a_193_47# a_476_413# VNB sky130_fd_pr__special_nfet_01v8 ad=0.0671 pd=0.745 as=0.119 ps=1.09 w=0.39 l=0.15
X9 a_193_47# a_27_47# VPWR VPB sky130_fd_pr__pfet_01v8_hvt ad=0.166 pd=1.8 as=0.0864 ps=0.91 w=0.64 l=0.15
X10 GCLK a_957_369# VGND VNB sky130_fd_pr__nfet_01v8 ad=0.169 pd=1.82 as=0.097 ps=0.975 w=0.65 l=0.15
X11 VPWR a_642_307# a_600_413# VPB sky130_fd_pr__pfet_01v8_hvt ad=0.109 pd=1.36 as=0.0441 ps=0.63 w=0.42 l=0.15
X12 a_476_413# a_27_47# a_396_119# VNB sky130_fd_pr__nfet_01v8 ad=0.119 pd=1.09 as=0.117 ps=1.09 w=0.42 l=0.15
X13 VPWR CLK a_957_369# VPB sky130_fd_pr__pfet_01v8_hvt ad=0.149 pd=1.33 as=0.203 ps=1.27 w=0.64 l=0.15
X14 a_642_307# a_476_413# VGND VNB sky130_fd_pr__nfet_01v8 ad=0.169 pd=1.82 as=0.118 ps=1.04 w=0.65 l=0.15
X15 a_600_413# a_27_47# a_476_413# VPB sky130_fd_pr__pfet_01v8_hvt ad=0.0441 pd=0.63 as=0.0987 ps=0.89 w=0.42 l=0.15
X16 VPWR a_476_413# a_642_307# VPB sky130_fd_pr__pfet_01v8_hvt ad=0.149 pd=1.33 as=0.27 ps=2.54 w=1 l=0.15
X17 VGND a_642_307# a_651_47# VNB sky130_fd_pr__nfet_01v8 ad=0.118 pd=1.04 as=0.0671 ps=0.745 w=0.42 l=0.15
X18 VGND CLK a_27_47# VNB sky130_fd_pr__nfet_01v8 ad=0.0567 pd=0.69 as=0.109 ps=1.36 w=0.42 l=0.15
X19 a_396_119# GATE VGND VNB sky130_fd_pr__nfet_01v8 ad=0.117 pd=1.09 as=0.128 ps=1.45 w=0.42 l=0.15
.ends

.subckt sky130_fd_sc_hd__dfrtp_2 VGND VPWR VPB VNB CLK D RESET_B Q
X0 a_805_47# a_761_289# a_639_47# VNB sky130_fd_pr__nfet_01v8 ad=0.0441 pd=0.63 as=0.14 ps=1.1 w=0.42 l=0.15
X1 a_1217_47# a_27_47# a_1108_47# VNB sky130_fd_pr__special_nfet_01v8 ad=0.0669 pd=0.75 as=0.0711 ps=0.755 w=0.36 l=0.15
X2 VGND a_1283_21# Q VNB sky130_fd_pr__nfet_01v8 ad=0.169 pd=1.82 as=0.0878 ps=0.92 w=0.65 l=0.15
X3 a_1283_21# a_1108_47# a_1462_47# VNB sky130_fd_pr__nfet_01v8 ad=0.109 pd=1.36 as=0.064 ps=0.725 w=0.42 l=0.15
X4 a_651_413# a_27_47# a_543_47# VPB sky130_fd_pr__pfet_01v8_hvt ad=0.116 pd=0.97 as=0.0724 ps=0.765 w=0.42 l=0.15
X5 VPWR a_1283_21# Q VPB sky130_fd_pr__pfet_01v8_hvt ad=0.26 pd=2.52 as=0.135 ps=1.27 w=1 l=0.15
X6 a_1108_47# a_193_47# a_761_289# VNB sky130_fd_pr__special_nfet_01v8 ad=0.0711 pd=0.755 as=0.0999 ps=0.985 w=0.36 l=0.15
X7 VGND RESET_B a_805_47# VNB sky130_fd_pr__nfet_01v8 ad=0.135 pd=1.15 as=0.0441 ps=0.63 w=0.42 l=0.15
X8 Q a_1283_21# VPWR VPB sky130_fd_pr__pfet_01v8_hvt ad=0.135 pd=1.27 as=0.301 ps=2.66 w=1 l=0.15
X9 VPWR CLK a_27_47# VPB sky130_fd_pr__pfet_01v8_hvt ad=0.0864 pd=0.91 as=0.166 ps=1.8 w=0.64 l=0.15
X10 a_448_47# D VPWR VPB sky130_fd_pr__pfet_01v8_hvt ad=0.0651 pd=0.73 as=0.109 ps=1.36 w=0.42 l=0.15
X11 a_761_289# a_543_47# VGND VNB sky130_fd_pr__nfet_01v8 ad=0.0999 pd=0.985 as=0.135 ps=1.15 w=0.64 l=0.15
X12 a_193_47# a_27_47# VGND VNB sky130_fd_pr__nfet_01v8 ad=0.109 pd=1.36 as=0.0567 ps=0.69 w=0.42 l=0.15
X13 a_1108_47# a_27_47# a_761_289# VPB sky130_fd_pr__pfet_01v8_hvt ad=0.0588 pd=0.7 as=0.129 ps=1.18 w=0.42 l=0.15
X14 a_1462_47# RESET_B VGND VNB sky130_fd_pr__nfet_01v8 ad=0.064 pd=0.725 as=0.125 ps=1.01 w=0.42 l=0.15
X15 a_543_47# a_27_47# a_448_47# VNB sky130_fd_pr__special_nfet_01v8 ad=0.0594 pd=0.69 as=0.066 ps=0.745 w=0.36 l=0.15
X16 a_543_47# a_193_47# a_448_47# VPB sky130_fd_pr__pfet_01v8_hvt ad=0.0724 pd=0.765 as=0.0651 ps=0.73 w=0.42 l=0.15
X17 a_448_47# D VGND VNB sky130_fd_pr__nfet_01v8 ad=0.066 pd=0.745 as=0.221 ps=1.89 w=0.42 l=0.15
X18 VPWR a_1283_21# a_1270_413# VPB sky130_fd_pr__pfet_01v8_hvt ad=0.0819 pd=0.81 as=0.0567 ps=0.69 w=0.42 l=0.15
X19 VPWR a_1108_47# a_1283_21# VPB sky130_fd_pr__pfet_01v8_hvt ad=0.113 pd=1.38 as=0.0567 ps=0.69 w=0.42 l=0.15
X20 a_1270_413# a_193_47# a_1108_47# VPB sky130_fd_pr__pfet_01v8_hvt ad=0.0567 pd=0.69 as=0.0588 ps=0.7 w=0.42 l=0.15
X21 a_193_47# a_27_47# VPWR VPB sky130_fd_pr__pfet_01v8_hvt ad=0.166 pd=1.8 as=0.0864 ps=0.91 w=0.64 l=0.15
X22 a_1283_21# RESET_B VPWR VPB sky130_fd_pr__pfet_01v8_hvt ad=0.0567 pd=0.69 as=0.0819 ps=0.81 w=0.42 l=0.15
X23 VPWR a_761_289# a_651_413# VPB sky130_fd_pr__pfet_01v8_hvt ad=0.0703 pd=0.755 as=0.116 ps=0.97 w=0.42 l=0.15
X24 Q a_1283_21# VGND VNB sky130_fd_pr__nfet_01v8 ad=0.0878 pd=0.92 as=0.209 ps=2.02 w=0.65 l=0.15
X25 a_639_47# a_193_47# a_543_47# VNB sky130_fd_pr__special_nfet_01v8 ad=0.14 pd=1.1 as=0.0594 ps=0.69 w=0.36 l=0.15
X26 VGND a_1283_21# a_1217_47# VNB sky130_fd_pr__nfet_01v8 ad=0.125 pd=1.01 as=0.0669 ps=0.75 w=0.42 l=0.15
X27 a_651_413# RESET_B VPWR VPB sky130_fd_pr__pfet_01v8_hvt ad=0.109 pd=1.36 as=0.0703 ps=0.755 w=0.42 l=0.15
X28 VGND CLK a_27_47# VNB sky130_fd_pr__nfet_01v8 ad=0.0567 pd=0.69 as=0.109 ps=1.36 w=0.42 l=0.15
X29 a_761_289# a_543_47# VPWR VPB sky130_fd_pr__pfet_01v8_hvt ad=0.129 pd=1.18 as=0.218 ps=2.2 w=0.84 l=0.15
.ends

.subckt sky130_fd_sc_hd__and2_0 VNB VPB VPWR VGND X B A
X0 VPWR B a_40_47# VPB sky130_fd_pr__pfet_01v8_hvt ad=0.184 pd=1.26 as=0.0609 ps=0.71 w=0.42 l=0.15
X1 X a_40_47# VPWR VPB sky130_fd_pr__pfet_01v8_hvt ad=0.17 pd=1.81 as=0.184 ps=1.26 w=0.64 l=0.15
X2 VGND B a_123_47# VNB sky130_fd_pr__nfet_01v8 ad=0.0966 pd=0.88 as=0.0441 ps=0.63 w=0.42 l=0.15
X3 X a_40_47# VGND VNB sky130_fd_pr__nfet_01v8 ad=0.111 pd=1.37 as=0.0966 ps=0.88 w=0.42 l=0.15
X4 a_123_47# A a_40_47# VNB sky130_fd_pr__nfet_01v8 ad=0.0441 pd=0.63 as=0.111 ps=1.37 w=0.42 l=0.15
X5 a_40_47# A VPWR VPB sky130_fd_pr__pfet_01v8_hvt ad=0.0609 pd=0.71 as=0.111 ps=1.37 w=0.42 l=0.15
.ends

.subckt sky130_fd_sc_hd__clkinv_8 VNB VPB VGND VPWR A Y
X0 Y A VGND VNB sky130_fd_pr__nfet_01v8 ad=0.0588 pd=0.7 as=0.111 ps=1.37 w=0.42 l=0.15
X1 VPWR A Y VPB sky130_fd_pr__pfet_01v8_hvt ad=0.135 pd=1.27 as=0.135 ps=1.27 w=1 l=0.15
X2 Y A VGND VNB sky130_fd_pr__nfet_01v8 ad=0.0588 pd=0.7 as=0.0588 ps=0.7 w=0.42 l=0.15
X3 Y A VGND VNB sky130_fd_pr__nfet_01v8 ad=0.0588 pd=0.7 as=0.0588 ps=0.7 w=0.42 l=0.15
X4 Y A VPWR VPB sky130_fd_pr__pfet_01v8_hvt ad=0.135 pd=1.27 as=0.135 ps=1.27 w=1 l=0.15
X5 VPWR A Y VPB sky130_fd_pr__pfet_01v8_hvt ad=0.138 pd=1.27 as=0.135 ps=1.27 w=1 l=0.15
X6 VPWR A Y VPB sky130_fd_pr__pfet_01v8_hvt ad=0.135 pd=1.27 as=0.135 ps=1.27 w=1 l=0.15
X7 Y A VGND VNB sky130_fd_pr__nfet_01v8 ad=0.0588 pd=0.7 as=0.0588 ps=0.7 w=0.42 l=0.15
X8 Y A VPWR VPB sky130_fd_pr__pfet_01v8_hvt ad=0.135 pd=1.27 as=0.135 ps=1.27 w=1 l=0.15
X9 VGND A Y VNB sky130_fd_pr__nfet_01v8 ad=0.0588 pd=0.7 as=0.0588 ps=0.7 w=0.42 l=0.15
X10 Y A VPWR VPB sky130_fd_pr__pfet_01v8_hvt ad=0.135 pd=1.27 as=0.138 ps=1.27 w=1 l=0.15
X11 VPWR A Y VPB sky130_fd_pr__pfet_01v8_hvt ad=0.26 pd=2.52 as=0.135 ps=1.27 w=1 l=0.15
X12 VGND A Y VNB sky130_fd_pr__nfet_01v8 ad=0.0588 pd=0.7 as=0.0588 ps=0.7 w=0.42 l=0.15
X13 VPWR A Y VPB sky130_fd_pr__pfet_01v8_hvt ad=0.135 pd=1.27 as=0.135 ps=1.27 w=1 l=0.15
X14 Y A VPWR VPB sky130_fd_pr__pfet_01v8_hvt ad=0.135 pd=1.27 as=0.135 ps=1.27 w=1 l=0.15
X15 VGND A Y VNB sky130_fd_pr__nfet_01v8 ad=0.0588 pd=0.7 as=0.0588 ps=0.7 w=0.42 l=0.15
X16 VPWR A Y VPB sky130_fd_pr__pfet_01v8_hvt ad=0.135 pd=1.27 as=0.135 ps=1.27 w=1 l=0.15
X17 Y A VPWR VPB sky130_fd_pr__pfet_01v8_hvt ad=0.135 pd=1.27 as=0.135 ps=1.27 w=1 l=0.15
X18 Y A VPWR VPB sky130_fd_pr__pfet_01v8_hvt ad=0.135 pd=1.27 as=0.26 ps=2.52 w=1 l=0.15
X19 VGND A Y VNB sky130_fd_pr__nfet_01v8 ad=0.111 pd=1.37 as=0.0588 ps=0.7 w=0.42 l=0.15
.ends

.subckt sky130_fd_sc_hd__inv_1 VPB VNB VGND VPWR A Y
X0 Y A VGND VNB sky130_fd_pr__nfet_01v8 ad=0.169 pd=1.82 as=0.169 ps=1.82 w=0.65 l=0.15
X1 Y A VPWR VPB sky130_fd_pr__pfet_01v8_hvt ad=0.26 pd=2.52 as=0.26 ps=2.52 w=1 l=0.15
.ends

.subckt sky130_fd_sc_hd__nand2_1 VPB VNB VGND VPWR A Y B
X0 VPWR A Y VPB sky130_fd_pr__pfet_01v8_hvt ad=0.26 pd=2.52 as=0.135 ps=1.27 w=1 l=0.15
X1 Y A a_113_47# VNB sky130_fd_pr__nfet_01v8 ad=0.169 pd=1.82 as=0.0878 ps=0.92 w=0.65 l=0.15
X2 a_113_47# B VGND VNB sky130_fd_pr__nfet_01v8 ad=0.0878 pd=0.92 as=0.169 ps=1.82 w=0.65 l=0.15
X3 Y B VPWR VPB sky130_fd_pr__pfet_01v8_hvt ad=0.135 pd=1.27 as=0.26 ps=2.52 w=1 l=0.15
.ends

.subckt sky130_fd_sc_hd__nand4_4 A D C B Y VPWR VGND VPB VNB
X0 a_27_47# C a_445_47# VNB sky130_fd_pr__nfet_01v8 ad=0.0878 pd=0.92 as=0.0878 ps=0.92 w=0.65 l=0.15
X1 a_27_47# C a_445_47# VNB sky130_fd_pr__nfet_01v8 ad=0.169 pd=1.82 as=0.0878 ps=0.92 w=0.65 l=0.15
X2 Y C VPWR VPB sky130_fd_pr__pfet_01v8_hvt ad=0.135 pd=1.27 as=0.135 ps=1.27 w=1 l=0.15
X3 VPWR D Y VPB sky130_fd_pr__pfet_01v8_hvt ad=0.135 pd=1.27 as=0.135 ps=1.27 w=1 l=0.15
X4 VPWR A Y VPB sky130_fd_pr__pfet_01v8_hvt ad=0.26 pd=2.52 as=0.135 ps=1.27 w=1 l=0.15
X5 Y A VPWR VPB sky130_fd_pr__pfet_01v8_hvt ad=0.135 pd=1.27 as=0.135 ps=1.27 w=1 l=0.15
X6 a_445_47# B a_803_47# VNB sky130_fd_pr__nfet_01v8 ad=0.0878 pd=0.92 as=0.0878 ps=0.92 w=0.65 l=0.15
X7 Y D VPWR VPB sky130_fd_pr__pfet_01v8_hvt ad=0.135 pd=1.27 as=0.135 ps=1.27 w=1 l=0.15
X8 a_445_47# B a_803_47# VNB sky130_fd_pr__nfet_01v8 ad=0.0878 pd=0.92 as=0.169 ps=1.82 w=0.65 l=0.15
X9 VPWR D Y VPB sky130_fd_pr__pfet_01v8_hvt ad=0.135 pd=1.27 as=0.135 ps=1.27 w=1 l=0.15
X10 VPWR A Y VPB sky130_fd_pr__pfet_01v8_hvt ad=0.135 pd=1.27 as=0.135 ps=1.27 w=1 l=0.15
X11 a_27_47# D VGND VNB sky130_fd_pr__nfet_01v8 ad=0.0878 pd=0.92 as=0.0878 ps=0.92 w=0.65 l=0.15
X12 a_27_47# D VGND VNB sky130_fd_pr__nfet_01v8 ad=0.0878 pd=0.92 as=0.0878 ps=0.92 w=0.65 l=0.15
X13 Y A a_803_47# VNB sky130_fd_pr__nfet_01v8 ad=0.0878 pd=0.92 as=0.107 ps=0.98 w=0.65 l=0.15
X14 Y A a_803_47# VNB sky130_fd_pr__nfet_01v8 ad=0.0878 pd=0.92 as=0.0878 ps=0.92 w=0.65 l=0.15
X15 a_803_47# B a_445_47# VNB sky130_fd_pr__nfet_01v8 ad=0.107 pd=0.98 as=0.0878 ps=0.92 w=0.65 l=0.15
X16 VPWR C Y VPB sky130_fd_pr__pfet_01v8_hvt ad=0.395 pd=1.79 as=0.135 ps=1.27 w=1 l=0.15
X17 a_803_47# B a_445_47# VNB sky130_fd_pr__nfet_01v8 ad=0.0878 pd=0.92 as=0.0878 ps=0.92 w=0.65 l=0.15
X18 VGND D a_27_47# VNB sky130_fd_pr__nfet_01v8 ad=0.0878 pd=0.92 as=0.0878 ps=0.92 w=0.65 l=0.15
X19 a_445_47# C a_27_47# VNB sky130_fd_pr__nfet_01v8 ad=0.0878 pd=0.92 as=0.0878 ps=0.92 w=0.65 l=0.15
X20 Y C VPWR VPB sky130_fd_pr__pfet_01v8_hvt ad=0.135 pd=1.27 as=0.135 ps=1.27 w=1 l=0.15
X21 a_803_47# A Y VNB sky130_fd_pr__nfet_01v8 ad=0.0878 pd=0.92 as=0.0878 ps=0.92 w=0.65 l=0.15
X22 VPWR B Y VPB sky130_fd_pr__pfet_01v8_hvt ad=0.165 pd=1.33 as=0.135 ps=1.27 w=1 l=0.15
X23 Y A VPWR VPB sky130_fd_pr__pfet_01v8_hvt ad=0.135 pd=1.27 as=0.165 ps=1.33 w=1 l=0.15
X24 a_445_47# C a_27_47# VNB sky130_fd_pr__nfet_01v8 ad=0.0878 pd=0.92 as=0.0878 ps=0.92 w=0.65 l=0.15
X25 a_803_47# A Y VNB sky130_fd_pr__nfet_01v8 ad=0.169 pd=1.82 as=0.0878 ps=0.92 w=0.65 l=0.15
X26 VPWR C Y VPB sky130_fd_pr__pfet_01v8_hvt ad=0.135 pd=1.27 as=0.135 ps=1.27 w=1 l=0.15
X27 Y B VPWR VPB sky130_fd_pr__pfet_01v8_hvt ad=0.135 pd=1.27 as=0.135 ps=1.27 w=1 l=0.15
X28 VPWR B Y VPB sky130_fd_pr__pfet_01v8_hvt ad=0.135 pd=1.27 as=0.135 ps=1.27 w=1 l=0.15
X29 Y D VPWR VPB sky130_fd_pr__pfet_01v8_hvt ad=0.135 pd=1.27 as=0.26 ps=2.52 w=1 l=0.15
X30 Y B VPWR VPB sky130_fd_pr__pfet_01v8_hvt ad=0.135 pd=1.27 as=0.395 ps=1.79 w=1 l=0.15
X31 VGND D a_27_47# VNB sky130_fd_pr__nfet_01v8 ad=0.0878 pd=0.92 as=0.169 ps=1.82 w=0.65 l=0.15
.ends

.subckt sky130_fd_sc_hd__conb_1 LO HI VPB VNB VGND VPWR
X0 VPWR HI sky130_fd_pr__res_generic_po w=0.48 l=0.045
X1 LO VGND sky130_fd_pr__res_generic_po w=0.48 l=0.045
.ends

.subckt sky130_fd_sc_hd__xor2_2 VPWR VGND X B A VPB VNB
X0 a_27_297# A VPWR VPB sky130_fd_pr__pfet_01v8_hvt ad=0.135 pd=1.27 as=0.135 ps=1.27 w=1 l=0.15
X1 a_470_47# A VGND VNB sky130_fd_pr__nfet_01v8 ad=0.0878 pd=0.92 as=0.0878 ps=0.92 w=0.65 l=0.15
X2 a_470_297# A VPWR VPB sky130_fd_pr__pfet_01v8_hvt ad=0.135 pd=1.27 as=0.135 ps=1.27 w=1 l=0.15
X3 VPWR A a_470_297# VPB sky130_fd_pr__pfet_01v8_hvt ad=0.135 pd=1.27 as=0.26 ps=2.52 w=1 l=0.15
X4 a_112_47# B VGND VNB sky130_fd_pr__nfet_01v8 ad=0.0878 pd=0.92 as=0.0878 ps=0.92 w=0.65 l=0.15
X5 a_470_47# B X VNB sky130_fd_pr__nfet_01v8 ad=0.169 pd=1.82 as=0.106 ps=0.975 w=0.65 l=0.15
X6 VGND A a_112_47# VNB sky130_fd_pr__nfet_01v8 ad=0.0878 pd=0.92 as=0.0878 ps=0.92 w=0.65 l=0.15
X7 a_112_47# A VGND VNB sky130_fd_pr__nfet_01v8 ad=0.0878 pd=0.92 as=0.179 ps=1.85 w=0.65 l=0.15
X8 VGND B a_112_47# VNB sky130_fd_pr__nfet_01v8 ad=0.169 pd=1.82 as=0.0878 ps=0.92 w=0.65 l=0.15
X9 VPWR A a_27_297# VPB sky130_fd_pr__pfet_01v8_hvt ad=0.135 pd=1.27 as=0.275 ps=2.55 w=1 l=0.15
X10 a_470_297# B VPWR VPB sky130_fd_pr__pfet_01v8_hvt ad=0.26 pd=2.52 as=0.162 ps=1.33 w=1 l=0.15
X11 X a_112_47# VGND VNB sky130_fd_pr__nfet_01v8 ad=0.0878 pd=0.92 as=0.169 ps=1.82 w=0.65 l=0.15
X12 VPWR B a_470_297# VPB sky130_fd_pr__pfet_01v8_hvt ad=0.162 pd=1.33 as=0.135 ps=1.27 w=1 l=0.15
X13 VGND a_112_47# X VNB sky130_fd_pr__nfet_01v8 ad=0.169 pd=1.82 as=0.0878 ps=0.92 w=0.65 l=0.15
X14 VGND A a_470_47# VNB sky130_fd_pr__nfet_01v8 ad=0.0878 pd=0.92 as=0.169 ps=1.82 w=0.65 l=0.15
X15 a_27_297# B a_112_47# VPB sky130_fd_pr__pfet_01v8_hvt ad=0.26 pd=2.52 as=0.135 ps=1.27 w=1 l=0.15
X16 X a_112_47# a_470_297# VPB sky130_fd_pr__pfet_01v8_hvt ad=0.135 pd=1.27 as=0.26 ps=2.52 w=1 l=0.15
X17 a_470_297# a_112_47# X VPB sky130_fd_pr__pfet_01v8_hvt ad=0.28 pd=2.56 as=0.135 ps=1.27 w=1 l=0.15
X18 X B a_470_47# VNB sky130_fd_pr__nfet_01v8 ad=0.106 pd=0.975 as=0.0878 ps=0.92 w=0.65 l=0.15
X19 a_112_47# B a_27_297# VPB sky130_fd_pr__pfet_01v8_hvt ad=0.135 pd=1.27 as=0.135 ps=1.27 w=1 l=0.15
.ends

.subckt sky130_fd_sc_hd__or4_1 VPWR VGND VPB VNB B D C A X
X0 a_27_297# B VGND VNB sky130_fd_pr__nfet_01v8 ad=0.0567 pd=0.69 as=0.0567 ps=0.69 w=0.42 l=0.15
X1 a_27_297# D VGND VNB sky130_fd_pr__nfet_01v8 ad=0.0693 pd=0.75 as=0.109 ps=1.36 w=0.42 l=0.15
X2 a_277_297# B a_205_297# VPB sky130_fd_pr__pfet_01v8_hvt ad=0.0693 pd=0.75 as=0.0441 ps=0.63 w=0.42 l=0.15
X3 VPWR A a_277_297# VPB sky130_fd_pr__pfet_01v8_hvt ad=0.148 pd=1.34 as=0.0693 ps=0.75 w=0.42 l=0.15
X4 X a_27_297# VGND VNB sky130_fd_pr__nfet_01v8 ad=0.176 pd=1.84 as=0.102 ps=0.99 w=0.65 l=0.15
X5 a_205_297# C a_109_297# VPB sky130_fd_pr__pfet_01v8_hvt ad=0.0441 pd=0.63 as=0.0693 ps=0.75 w=0.42 l=0.15
X6 X a_27_297# VPWR VPB sky130_fd_pr__pfet_01v8_hvt ad=0.27 pd=2.54 as=0.148 ps=1.34 w=1 l=0.15
X7 VGND C a_27_297# VNB sky130_fd_pr__nfet_01v8 ad=0.0567 pd=0.69 as=0.0693 ps=0.75 w=0.42 l=0.15
X8 a_109_297# D a_27_297# VPB sky130_fd_pr__pfet_01v8_hvt ad=0.0693 pd=0.75 as=0.109 ps=1.36 w=0.42 l=0.15
X9 VGND A a_27_297# VNB sky130_fd_pr__nfet_01v8 ad=0.102 pd=0.99 as=0.0567 ps=0.69 w=0.42 l=0.15
.ends

.subckt sky130_fd_sc_hd__a21oi_4 VNB VPB VGND VPWR A2 B1 Y A1
X0 a_28_297# B1 Y VPB sky130_fd_pr__pfet_01v8_hvt ad=0.14 pd=1.28 as=0.14 ps=1.28 w=1 l=0.15
X1 a_462_47# A1 Y VNB sky130_fd_pr__nfet_01v8 ad=0.091 pd=0.93 as=0.091 ps=0.93 w=0.65 l=0.15
X2 Y B1 a_28_297# VPB sky130_fd_pr__pfet_01v8_hvt ad=0.14 pd=1.28 as=0.26 ps=2.52 w=1 l=0.15
X3 Y B1 VGND VNB sky130_fd_pr__nfet_01v8 ad=0.091 pd=0.93 as=0.091 ps=0.93 w=0.65 l=0.15
X4 a_462_47# A1 Y VNB sky130_fd_pr__nfet_01v8 ad=0.091 pd=0.93 as=0.091 ps=0.93 w=0.65 l=0.15
X5 a_28_297# A2 VPWR VPB sky130_fd_pr__pfet_01v8_hvt ad=0.14 pd=1.28 as=0.14 ps=1.28 w=1 l=0.15
X6 a_462_47# A2 VGND VNB sky130_fd_pr__nfet_01v8 ad=0.091 pd=0.93 as=0.104 ps=0.97 w=0.65 l=0.15
X7 Y B1 a_28_297# VPB sky130_fd_pr__pfet_01v8_hvt ad=0.14 pd=1.28 as=0.14 ps=1.28 w=1 l=0.15
X8 VGND B1 Y VNB sky130_fd_pr__nfet_01v8 ad=0.104 pd=0.97 as=0.091 ps=0.93 w=0.65 l=0.15
X9 VGND B1 Y VNB sky130_fd_pr__nfet_01v8 ad=0.091 pd=0.93 as=0.091 ps=0.93 w=0.65 l=0.15
X10 Y A1 a_462_47# VNB sky130_fd_pr__nfet_01v8 ad=0.091 pd=0.93 as=0.091 ps=0.93 w=0.65 l=0.15
X11 a_28_297# A1 VPWR VPB sky130_fd_pr__pfet_01v8_hvt ad=0.14 pd=1.28 as=0.145 ps=1.29 w=1 l=0.15
X12 VPWR A2 a_28_297# VPB sky130_fd_pr__pfet_01v8_hvt ad=0.14 pd=1.28 as=0.14 ps=1.28 w=1 l=0.15
X13 Y B1 VGND VNB sky130_fd_pr__nfet_01v8 ad=0.091 pd=0.93 as=0.172 ps=1.83 w=0.65 l=0.15
X14 VGND A2 a_462_47# VNB sky130_fd_pr__nfet_01v8 ad=0.172 pd=1.83 as=0.091 ps=0.93 w=0.65 l=0.15
X15 a_28_297# B1 Y VPB sky130_fd_pr__pfet_01v8_hvt ad=0.155 pd=1.31 as=0.14 ps=1.28 w=1 l=0.15
X16 VPWR A1 a_28_297# VPB sky130_fd_pr__pfet_01v8_hvt ad=0.14 pd=1.28 as=0.14 ps=1.28 w=1 l=0.15
X17 a_28_297# A1 VPWR VPB sky130_fd_pr__pfet_01v8_hvt ad=0.14 pd=1.28 as=0.14 ps=1.28 w=1 l=0.15
X18 VGND A2 a_462_47# VNB sky130_fd_pr__nfet_01v8 ad=0.091 pd=0.93 as=0.091 ps=0.93 w=0.65 l=0.15
X19 VPWR A2 a_28_297# VPB sky130_fd_pr__pfet_01v8_hvt ad=0.145 pd=1.29 as=0.155 ps=1.31 w=1 l=0.15
X20 a_28_297# A2 VPWR VPB sky130_fd_pr__pfet_01v8_hvt ad=0.265 pd=2.53 as=0.14 ps=1.28 w=1 l=0.15
X21 Y A1 a_462_47# VNB sky130_fd_pr__nfet_01v8 ad=0.091 pd=0.93 as=0.091 ps=0.93 w=0.65 l=0.15
X22 a_462_47# A2 VGND VNB sky130_fd_pr__nfet_01v8 ad=0.091 pd=0.93 as=0.091 ps=0.93 w=0.65 l=0.15
X23 VPWR A1 a_28_297# VPB sky130_fd_pr__pfet_01v8_hvt ad=0.14 pd=1.28 as=0.14 ps=1.28 w=1 l=0.15
.ends

.subckt sky130_fd_sc_hd__a22oi_1 VPWR VGND VPB VNB B2 B1 Y A1 A2
X0 Y B1 a_109_47# VNB sky130_fd_pr__nfet_01v8 ad=0.169 pd=1.82 as=0.0747 ps=0.88 w=0.65 l=0.15
X1 Y B1 a_109_297# VPB sky130_fd_pr__pfet_01v8_hvt ad=0.26 pd=2.52 as=0.135 ps=1.27 w=1 l=0.15
X2 VPWR A2 a_109_297# VPB sky130_fd_pr__pfet_01v8_hvt ad=0.3 pd=2.6 as=0.135 ps=1.27 w=1 l=0.15
X3 a_109_297# A1 VPWR VPB sky130_fd_pr__pfet_01v8_hvt ad=0.135 pd=1.27 as=0.26 ps=2.52 w=1 l=0.15
X4 a_381_47# A1 Y VNB sky130_fd_pr__nfet_01v8 ad=0.0683 pd=0.86 as=0.169 ps=1.82 w=0.65 l=0.15
X5 a_109_297# B2 Y VPB sky130_fd_pr__pfet_01v8_hvt ad=0.135 pd=1.27 as=0.26 ps=2.52 w=1 l=0.15
X6 a_109_47# B2 VGND VNB sky130_fd_pr__nfet_01v8 ad=0.0747 pd=0.88 as=0.169 ps=1.82 w=0.65 l=0.15
X7 VGND A2 a_381_47# VNB sky130_fd_pr__nfet_01v8 ad=0.234 pd=2.02 as=0.0683 ps=0.86 w=0.65 l=0.15
.ends

.subckt sky130_fd_sc_hd__o2bb2ai_1 VPB VNB VGND VPWR B1 B2 Y A2_N A1_N
X0 VPWR A2_N a_112_297# VPB sky130_fd_pr__pfet_01v8_hvt ad=0.42 pd=1.84 as=0.135 ps=1.27 w=1 l=0.15
X1 Y a_112_297# VPWR VPB sky130_fd_pr__pfet_01v8_hvt ad=0.135 pd=1.27 as=0.42 ps=1.84 w=1 l=0.15
X2 VGND B2 a_394_47# VNB sky130_fd_pr__nfet_01v8 ad=0.0878 pd=0.92 as=0.0878 ps=0.92 w=0.65 l=0.15
X3 a_112_297# A2_N a_112_47# VNB sky130_fd_pr__nfet_01v8 ad=0.241 pd=2.04 as=0.0683 ps=0.86 w=0.65 l=0.15
X4 a_112_47# A1_N VGND VNB sky130_fd_pr__nfet_01v8 ad=0.0683 pd=0.86 as=0.179 ps=1.85 w=0.65 l=0.15
X5 a_112_297# A1_N VPWR VPB sky130_fd_pr__pfet_01v8_hvt ad=0.135 pd=1.27 as=0.275 ps=2.55 w=1 l=0.15
X6 VPWR B1 a_478_297# VPB sky130_fd_pr__pfet_01v8_hvt ad=0.275 pd=2.55 as=0.135 ps=1.27 w=1 l=0.15
X7 a_394_47# a_112_297# Y VNB sky130_fd_pr__nfet_01v8 ad=0.0878 pd=0.92 as=0.169 ps=1.82 w=0.65 l=0.15
X8 a_394_47# B1 VGND VNB sky130_fd_pr__nfet_01v8 ad=0.169 pd=1.82 as=0.0878 ps=0.92 w=0.65 l=0.15
X9 a_478_297# B2 Y VPB sky130_fd_pr__pfet_01v8_hvt ad=0.135 pd=1.27 as=0.135 ps=1.27 w=1 l=0.15
.ends

.subckt sky130_fd_sc_hd__nor4b_2 VNB VPB VGND VPWR A B C Y D_N
X0 VPWR D_N a_694_21# VPB sky130_fd_pr__pfet_01v8_hvt ad=0.109 pd=1.36 as=0.109 ps=1.36 w=0.42 l=0.15
X1 a_27_297# B a_277_297# VPB sky130_fd_pr__pfet_01v8_hvt ad=0.26 pd=2.52 as=0.135 ps=1.27 w=1 l=0.15
X2 a_474_297# a_694_21# Y VPB sky130_fd_pr__pfet_01v8_hvt ad=0.26 pd=2.52 as=0.135 ps=1.27 w=1 l=0.15
X3 a_277_297# B a_27_297# VPB sky130_fd_pr__pfet_01v8_hvt ad=0.135 pd=1.27 as=0.135 ps=1.27 w=1 l=0.15
X4 Y a_694_21# a_474_297# VPB sky130_fd_pr__pfet_01v8_hvt ad=0.135 pd=1.27 as=0.135 ps=1.27 w=1 l=0.15
X5 VGND C Y VNB sky130_fd_pr__nfet_01v8 ad=0.0878 pd=0.92 as=0.0878 ps=0.92 w=0.65 l=0.15
X6 VGND D_N a_694_21# VNB sky130_fd_pr__nfet_01v8 ad=0.109 pd=1.36 as=0.109 ps=1.36 w=0.42 l=0.15
X7 a_27_297# A VPWR VPB sky130_fd_pr__pfet_01v8_hvt ad=0.135 pd=1.27 as=0.135 ps=1.27 w=1 l=0.15
X8 VGND A Y VNB sky130_fd_pr__nfet_01v8 ad=0.0878 pd=0.92 as=0.0878 ps=0.92 w=0.65 l=0.15
X9 VGND B Y VNB sky130_fd_pr__nfet_01v8 ad=0.169 pd=1.82 as=0.0878 ps=0.92 w=0.65 l=0.15
X10 Y C VGND VNB sky130_fd_pr__nfet_01v8 ad=0.0878 pd=0.92 as=0.169 ps=1.82 w=0.65 l=0.15
X11 a_474_297# C a_277_297# VPB sky130_fd_pr__pfet_01v8_hvt ad=0.135 pd=1.27 as=0.135 ps=1.27 w=1 l=0.15
X12 Y B VGND VNB sky130_fd_pr__nfet_01v8 ad=0.0878 pd=0.92 as=0.0878 ps=0.92 w=0.65 l=0.15
X13 Y a_694_21# VGND VNB sky130_fd_pr__nfet_01v8 ad=0.0878 pd=0.92 as=0.0878 ps=0.92 w=0.65 l=0.15
X14 a_277_297# C a_474_297# VPB sky130_fd_pr__pfet_01v8_hvt ad=0.135 pd=1.27 as=0.26 ps=2.52 w=1 l=0.15
X15 VGND a_694_21# Y VNB sky130_fd_pr__nfet_01v8 ad=0.169 pd=1.82 as=0.0878 ps=0.92 w=0.65 l=0.15
X16 VPWR A a_27_297# VPB sky130_fd_pr__pfet_01v8_hvt ad=0.135 pd=1.27 as=0.26 ps=2.52 w=1 l=0.15
X17 Y A VGND VNB sky130_fd_pr__nfet_01v8 ad=0.0878 pd=0.92 as=0.169 ps=1.82 w=0.65 l=0.15
.ends

.subckt sky130_fd_sc_hd__a21oi_1 VPWR VGND VPB VNB A2 A1 B1 Y
X0 a_199_47# A1 Y VNB sky130_fd_pr__nfet_01v8 ad=0.0959 pd=0.945 as=0.091 ps=0.93 w=0.65 l=0.15
X1 a_113_297# A2 VPWR VPB sky130_fd_pr__pfet_01v8_hvt ad=0.265 pd=2.53 as=0.147 ps=1.29 w=1 l=0.15
X2 Y B1 VGND VNB sky130_fd_pr__nfet_01v8 ad=0.091 pd=0.93 as=0.172 ps=1.83 w=0.65 l=0.15
X3 VPWR A1 a_113_297# VPB sky130_fd_pr__pfet_01v8_hvt ad=0.147 pd=1.29 as=0.14 ps=1.28 w=1 l=0.15
X4 a_113_297# B1 Y VPB sky130_fd_pr__pfet_01v8_hvt ad=0.14 pd=1.28 as=0.265 ps=2.53 w=1 l=0.15
X5 VGND A2 a_199_47# VNB sky130_fd_pr__nfet_01v8 ad=0.172 pd=1.83 as=0.0959 ps=0.945 w=0.65 l=0.15
.ends

.subckt sky130_fd_sc_hd__a31oi_1 VGND VPWR VPB VNB A3 A2 A1 Y B1
X0 Y A1 a_181_47# VNB sky130_fd_pr__nfet_01v8 ad=0.106 pd=0.975 as=0.119 ps=1.01 w=0.65 l=0.15
X1 a_181_47# A2 a_109_47# VNB sky130_fd_pr__nfet_01v8 ad=0.119 pd=1.01 as=0.0683 ps=0.86 w=0.65 l=0.15
X2 VGND B1 Y VNB sky130_fd_pr__nfet_01v8 ad=0.176 pd=1.84 as=0.106 ps=0.975 w=0.65 l=0.15
X3 VPWR A2 a_109_297# VPB sky130_fd_pr__pfet_01v8_hvt ad=0.153 pd=1.3 as=0.135 ps=1.27 w=1 l=0.15
X4 Y B1 a_109_297# VPB sky130_fd_pr__pfet_01v8_hvt ad=0.27 pd=2.54 as=0.162 ps=1.33 w=1 l=0.15
X5 a_109_297# A1 VPWR VPB sky130_fd_pr__pfet_01v8_hvt ad=0.162 pd=1.33 as=0.153 ps=1.3 w=1 l=0.15
X6 a_109_297# A3 VPWR VPB sky130_fd_pr__pfet_01v8_hvt ad=0.135 pd=1.27 as=0.26 ps=2.52 w=1 l=0.15
X7 a_109_47# A3 VGND VNB sky130_fd_pr__nfet_01v8 ad=0.0683 pd=0.86 as=0.169 ps=1.82 w=0.65 l=0.15
.ends

.subckt sky130_fd_sc_hd__o21ai_2 VGND VPWR B1 A1 Y A2 VPB VNB
X0 VGND A2 a_29_47# VNB sky130_fd_pr__nfet_01v8 ad=0.127 pd=1.04 as=0.091 ps=0.93 w=0.65 l=0.15
X1 Y B1 a_29_47# VNB sky130_fd_pr__nfet_01v8 ad=0.091 pd=0.93 as=0.091 ps=0.93 w=0.65 l=0.15
X2 VPWR B1 Y VPB sky130_fd_pr__pfet_01v8_hvt ad=0.265 pd=2.53 as=0.14 ps=1.28 w=1 l=0.15
X3 VPWR A1 a_112_297# VPB sky130_fd_pr__pfet_01v8_hvt ad=0.16 pd=1.32 as=0.175 ps=1.35 w=1 l=0.15
X4 a_29_47# A2 VGND VNB sky130_fd_pr__nfet_01v8 ad=0.091 pd=0.93 as=0.091 ps=0.93 w=0.65 l=0.15
X5 Y A2 a_112_297# VPB sky130_fd_pr__pfet_01v8_hvt ad=0.14 pd=1.28 as=0.14 ps=1.28 w=1 l=0.15
X6 VGND A1 a_29_47# VNB sky130_fd_pr__nfet_01v8 ad=0.091 pd=0.93 as=0.172 ps=1.83 w=0.65 l=0.15
X7 a_112_297# A1 VPWR VPB sky130_fd_pr__pfet_01v8_hvt ad=0.14 pd=1.28 as=0.265 ps=2.53 w=1 l=0.15
X8 a_112_297# A2 Y VPB sky130_fd_pr__pfet_01v8_hvt ad=0.175 pd=1.35 as=0.14 ps=1.28 w=1 l=0.15
X9 a_29_47# B1 Y VNB sky130_fd_pr__nfet_01v8 ad=0.172 pd=1.83 as=0.091 ps=0.93 w=0.65 l=0.15
X10 Y B1 VPWR VPB sky130_fd_pr__pfet_01v8_hvt ad=0.14 pd=1.28 as=0.16 ps=1.32 w=1 l=0.15
X11 a_29_47# A1 VGND VNB sky130_fd_pr__nfet_01v8 ad=0.091 pd=0.93 as=0.127 ps=1.04 w=0.65 l=0.15
.ends

.subckt sky130_fd_sc_hd__dfrtn_1 VGND VPWR VPB VNB D RESET_B Q CLK_N
X0 a_805_47# a_761_289# a_639_47# VNB sky130_fd_pr__nfet_01v8 ad=0.0441 pd=0.63 as=0.14 ps=1.1 w=0.42 l=0.15
X1 a_1217_47# a_193_47# a_1108_47# VNB sky130_fd_pr__special_nfet_01v8 ad=0.0669 pd=0.75 as=0.0711 ps=0.755 w=0.36 l=0.15
X2 a_1283_21# a_1108_47# a_1462_47# VNB sky130_fd_pr__nfet_01v8 ad=0.109 pd=1.36 as=0.064 ps=0.725 w=0.42 l=0.15
X3 a_651_413# a_193_47# a_543_47# VPB sky130_fd_pr__pfet_01v8_hvt ad=0.116 pd=0.97 as=0.0724 ps=0.765 w=0.42 l=0.15
X4 a_1108_47# a_27_47# a_761_289# VNB sky130_fd_pr__special_nfet_01v8 ad=0.0711 pd=0.755 as=0.0999 ps=0.985 w=0.36 l=0.15
X5 VGND RESET_B a_805_47# VNB sky130_fd_pr__nfet_01v8 ad=0.135 pd=1.15 as=0.0441 ps=0.63 w=0.42 l=0.15
X6 Q a_1283_21# VPWR VPB sky130_fd_pr__pfet_01v8_hvt ad=0.26 pd=2.52 as=0.301 ps=2.66 w=1 l=0.15
X7 VPWR CLK_N a_27_47# VPB sky130_fd_pr__pfet_01v8_hvt ad=0.0864 pd=0.91 as=0.166 ps=1.8 w=0.64 l=0.15
X8 a_448_47# D VPWR VPB sky130_fd_pr__pfet_01v8_hvt ad=0.0651 pd=0.73 as=0.109 ps=1.36 w=0.42 l=0.15
X9 a_761_289# a_543_47# VGND VNB sky130_fd_pr__nfet_01v8 ad=0.0999 pd=0.985 as=0.135 ps=1.15 w=0.64 l=0.15
X10 a_193_47# a_27_47# VGND VNB sky130_fd_pr__nfet_01v8 ad=0.109 pd=1.36 as=0.0567 ps=0.69 w=0.42 l=0.15
X11 a_1108_47# a_193_47# a_761_289# VPB sky130_fd_pr__pfet_01v8_hvt ad=0.0588 pd=0.7 as=0.129 ps=1.18 w=0.42 l=0.15
X12 a_1462_47# RESET_B VGND VNB sky130_fd_pr__nfet_01v8 ad=0.064 pd=0.725 as=0.125 ps=1.01 w=0.42 l=0.15
X13 a_543_47# a_193_47# a_448_47# VNB sky130_fd_pr__special_nfet_01v8 ad=0.0594 pd=0.69 as=0.066 ps=0.745 w=0.36 l=0.15
X14 a_543_47# a_27_47# a_448_47# VPB sky130_fd_pr__pfet_01v8_hvt ad=0.0724 pd=0.765 as=0.0651 ps=0.73 w=0.42 l=0.15
X15 a_448_47# D VGND VNB sky130_fd_pr__nfet_01v8 ad=0.066 pd=0.745 as=0.221 ps=1.89 w=0.42 l=0.15
X16 VPWR a_1283_21# a_1270_413# VPB sky130_fd_pr__pfet_01v8_hvt ad=0.0819 pd=0.81 as=0.0567 ps=0.69 w=0.42 l=0.15
X17 VPWR a_1108_47# a_1283_21# VPB sky130_fd_pr__pfet_01v8_hvt ad=0.113 pd=1.38 as=0.0567 ps=0.69 w=0.42 l=0.15
X18 a_1270_413# a_27_47# a_1108_47# VPB sky130_fd_pr__pfet_01v8_hvt ad=0.0567 pd=0.69 as=0.0588 ps=0.7 w=0.42 l=0.15
X19 a_193_47# a_27_47# VPWR VPB sky130_fd_pr__pfet_01v8_hvt ad=0.166 pd=1.8 as=0.0864 ps=0.91 w=0.64 l=0.15
X20 a_1283_21# RESET_B VPWR VPB sky130_fd_pr__pfet_01v8_hvt ad=0.0567 pd=0.69 as=0.0819 ps=0.81 w=0.42 l=0.15
X21 VPWR a_761_289# a_651_413# VPB sky130_fd_pr__pfet_01v8_hvt ad=0.0703 pd=0.755 as=0.116 ps=0.97 w=0.42 l=0.15
X22 Q a_1283_21# VGND VNB sky130_fd_pr__nfet_01v8 ad=0.169 pd=1.82 as=0.209 ps=2.02 w=0.65 l=0.15
X23 a_639_47# a_27_47# a_543_47# VNB sky130_fd_pr__special_nfet_01v8 ad=0.14 pd=1.1 as=0.0594 ps=0.69 w=0.36 l=0.15
X24 VGND a_1283_21# a_1217_47# VNB sky130_fd_pr__nfet_01v8 ad=0.125 pd=1.01 as=0.0669 ps=0.75 w=0.42 l=0.15
X25 a_651_413# RESET_B VPWR VPB sky130_fd_pr__pfet_01v8_hvt ad=0.109 pd=1.36 as=0.0703 ps=0.755 w=0.42 l=0.15
X26 VGND CLK_N a_27_47# VNB sky130_fd_pr__nfet_01v8 ad=0.0567 pd=0.69 as=0.109 ps=1.36 w=0.42 l=0.15
X27 a_761_289# a_543_47# VPWR VPB sky130_fd_pr__pfet_01v8_hvt ad=0.129 pd=1.18 as=0.218 ps=2.2 w=0.84 l=0.15
.ends

.subckt sky130_fd_sc_hd__o21bai_1 VPB VNB VPWR VGND A1 B1_N Y A2
X0 a_388_297# A2 Y VPB sky130_fd_pr__pfet_01v8_hvt ad=0.127 pd=1.25 as=0.153 ps=1.3 w=1 l=0.15
X1 a_105_352# B1_N VGND VNB sky130_fd_pr__nfet_01v8 ad=0.109 pd=1.36 as=0.109 ps=1.36 w=0.42 l=0.15
X2 a_297_47# a_105_352# Y VNB sky130_fd_pr__nfet_01v8 ad=0.101 pd=0.96 as=0.169 ps=1.82 w=0.65 l=0.15
X3 a_297_47# A1 VGND VNB sky130_fd_pr__nfet_01v8 ad=0.169 pd=1.82 as=0.0878 ps=0.92 w=0.65 l=0.15
X4 VPWR A1 a_388_297# VPB sky130_fd_pr__pfet_01v8_hvt ad=0.28 pd=2.56 as=0.127 ps=1.25 w=1 l=0.15
X5 VGND A2 a_297_47# VNB sky130_fd_pr__nfet_01v8 ad=0.0878 pd=0.92 as=0.101 ps=0.96 w=0.65 l=0.15
X6 VPWR B1_N a_105_352# VPB sky130_fd_pr__pfet_01v8_hvt ad=0.178 pd=1.4 as=0.109 ps=1.36 w=0.42 l=0.15
X7 Y a_105_352# VPWR VPB sky130_fd_pr__pfet_01v8_hvt ad=0.153 pd=1.3 as=0.178 ps=1.4 w=1 l=0.15
.ends

.subckt sky130_fd_sc_hd__mux4_1 VNB VPB VGND VPWR A1 A0 S0 A3 A2 S1 X
X0 a_277_47# a_247_21# a_27_413# VPB sky130_fd_pr__pfet_01v8_hvt ad=0.0567 pd=0.69 as=0.109 ps=1.36 w=0.42 l=0.15
X1 VGND S0 a_247_21# VNB sky130_fd_pr__nfet_01v8 ad=0.109 pd=1.36 as=0.109 ps=1.36 w=0.42 l=0.15
X2 a_834_97# a_247_21# a_750_97# VNB sky130_fd_pr__nfet_01v8 ad=0.108 pd=1.36 as=0.0567 ps=0.69 w=0.42 l=0.15
X3 VGND A3 a_668_97# VNB sky130_fd_pr__nfet_01v8 ad=0.0567 pd=0.69 as=0.108 ps=1.36 w=0.42 l=0.15
X4 a_1290_413# S1 VPWR VPB sky130_fd_pr__pfet_01v8_hvt ad=0.109 pd=1.36 as=0.109 ps=1.36 w=0.42 l=0.15
X5 a_834_97# A2 VGND VNB sky130_fd_pr__nfet_01v8 ad=0.109 pd=1.36 as=0.0567 ps=0.69 w=0.42 l=0.15
X6 a_750_97# S0 a_757_363# VPB sky130_fd_pr__pfet_01v8_hvt ad=0.0567 pd=0.69 as=0.108 ps=1.36 w=0.42 l=0.15
X7 a_27_47# S0 a_277_47# VNB sky130_fd_pr__nfet_01v8 ad=0.109 pd=1.36 as=0.0852 ps=0.925 w=0.42 l=0.15
X8 X a_1478_413# VGND VNB sky130_fd_pr__nfet_01v8 ad=0.169 pd=1.82 as=0.169 ps=1.82 w=0.65 l=0.15
X9 VPWR A1 a_27_413# VPB sky130_fd_pr__pfet_01v8_hvt ad=0.0567 pd=0.69 as=0.109 ps=1.36 w=0.42 l=0.15
X10 VPWR S0 a_247_21# VPB sky130_fd_pr__pfet_01v8_hvt ad=0.108 pd=1.36 as=0.108 ps=1.36 w=0.42 l=0.15
X11 X a_1478_413# VPWR VPB sky130_fd_pr__pfet_01v8_hvt ad=0.26 pd=2.52 as=0.26 ps=2.52 w=1 l=0.15
X12 a_193_47# A0 VGND VNB sky130_fd_pr__nfet_01v8 ad=0.0567 pd=0.69 as=0.0567 ps=0.69 w=0.42 l=0.15
X13 a_750_97# a_1290_413# a_1478_413# VPB sky130_fd_pr__pfet_01v8_hvt ad=0.269 pd=2.12 as=0.0921 ps=0.99 w=0.42 l=0.15
X14 a_1478_413# S1 a_277_47# VPB sky130_fd_pr__pfet_01v8_hvt ad=0.0921 pd=0.99 as=0.109 ps=1.36 w=0.42 l=0.15
X15 a_1290_413# S1 VGND VNB sky130_fd_pr__nfet_01v8 ad=0.109 pd=1.36 as=0.109 ps=1.36 w=0.42 l=0.15
X16 a_277_47# a_247_21# a_193_47# VNB sky130_fd_pr__nfet_01v8 ad=0.0852 pd=0.925 as=0.0567 ps=0.69 w=0.42 l=0.15
X17 a_750_97# S0 a_668_97# VNB sky130_fd_pr__nfet_01v8 ad=0.0567 pd=0.69 as=0.109 ps=1.36 w=0.42 l=0.15
X18 a_923_363# a_247_21# a_750_97# VPB sky130_fd_pr__pfet_01v8_hvt ad=0.0901 pd=0.995 as=0.0567 ps=0.69 w=0.42 l=0.15
X19 a_757_363# A2 VPWR VPB sky130_fd_pr__pfet_01v8_hvt ad=0.109 pd=1.36 as=0.0567 ps=0.69 w=0.42 l=0.15
X20 VPWR A3 a_923_363# VPB sky130_fd_pr__pfet_01v8_hvt ad=0.0567 pd=0.69 as=0.0901 ps=0.995 w=0.42 l=0.15
X21 a_277_47# a_1290_413# a_1478_413# VNB sky130_fd_pr__nfet_01v8 ad=0.109 pd=1.36 as=0.151 ps=1.28 w=0.42 l=0.15
X22 a_193_413# A0 VPWR VPB sky130_fd_pr__pfet_01v8_hvt ad=0.109 pd=1.36 as=0.0567 ps=0.69 w=0.42 l=0.15
X23 a_193_413# S0 a_277_47# VPB sky130_fd_pr__pfet_01v8_hvt ad=0.108 pd=1.36 as=0.0567 ps=0.69 w=0.42 l=0.15
X24 VGND A1 a_27_47# VNB sky130_fd_pr__nfet_01v8 ad=0.0567 pd=0.69 as=0.109 ps=1.36 w=0.42 l=0.15
X25 a_1478_413# S1 a_750_97# VNB sky130_fd_pr__nfet_01v8 ad=0.151 pd=1.28 as=0.109 ps=1.36 w=0.42 l=0.15
.ends

.subckt sky130_fd_sc_hd__nand2b_1 VPB VNB VGND VPWR A_N B Y
X0 VGND A_N a_27_93# VNB sky130_fd_pr__nfet_01v8 ad=0.1 pd=0.985 as=0.109 ps=1.36 w=0.42 l=0.15
X1 Y a_27_93# a_206_47# VNB sky130_fd_pr__nfet_01v8 ad=0.169 pd=1.82 as=0.0878 ps=0.92 w=0.65 l=0.15
X2 a_206_47# B VGND VNB sky130_fd_pr__nfet_01v8 ad=0.0878 pd=0.92 as=0.1 ps=0.985 w=0.65 l=0.15
X3 VPWR a_27_93# Y VPB sky130_fd_pr__pfet_01v8_hvt ad=0.265 pd=2.53 as=0.135 ps=1.27 w=1 l=0.15
X4 Y B VPWR VPB sky130_fd_pr__pfet_01v8_hvt ad=0.135 pd=1.27 as=0.146 ps=1.34 w=1 l=0.15
X5 VPWR A_N a_27_93# VPB sky130_fd_pr__pfet_01v8_hvt ad=0.146 pd=1.34 as=0.109 ps=1.36 w=0.42 l=0.15
.ends

.subckt sky130_fd_sc_hd__and3_1 VGND VPWR X B A C VPB VNB
X0 VPWR A a_27_47# VPB sky130_fd_pr__pfet_01v8_hvt ad=0.0567 pd=0.69 as=0.109 ps=1.36 w=0.42 l=0.15
X1 VPWR C a_27_47# VPB sky130_fd_pr__pfet_01v8_hvt ad=0.142 pd=1.34 as=0.0662 ps=0.735 w=0.42 l=0.15
X2 a_181_47# B a_109_47# VNB sky130_fd_pr__nfet_01v8 ad=0.0441 pd=0.63 as=0.0441 ps=0.63 w=0.42 l=0.15
X3 VGND C a_181_47# VNB sky130_fd_pr__nfet_01v8 ad=0.132 pd=1.14 as=0.0441 ps=0.63 w=0.42 l=0.15
X4 a_27_47# B VPWR VPB sky130_fd_pr__pfet_01v8_hvt ad=0.0662 pd=0.735 as=0.0567 ps=0.69 w=0.42 l=0.15
X5 X a_27_47# VPWR VPB sky130_fd_pr__pfet_01v8_hvt ad=0.26 pd=2.52 as=0.142 ps=1.34 w=1 l=0.15
X6 X a_27_47# VGND VNB sky130_fd_pr__nfet_01v8 ad=0.169 pd=1.82 as=0.132 ps=1.14 w=0.65 l=0.15
X7 a_109_47# A a_27_47# VNB sky130_fd_pr__nfet_01v8 ad=0.0441 pd=0.63 as=0.109 ps=1.36 w=0.42 l=0.15
.ends

.subckt sky130_fd_sc_hd__a21o_1 VPWR VGND VPB VNB A2 A1 B1 X
X0 a_81_21# B1 VGND VNB sky130_fd_pr__nfet_01v8 ad=0.0894 pd=0.925 as=0.257 ps=1.44 w=0.65 l=0.15
X1 a_299_297# B1 a_81_21# VPB sky130_fd_pr__pfet_01v8_hvt ad=0.138 pd=1.27 as=0.26 ps=2.52 w=1 l=0.15
X2 VPWR a_81_21# X VPB sky130_fd_pr__pfet_01v8_hvt ad=0.26 pd=2.52 as=0.26 ps=2.52 w=1 l=0.15
X3 VPWR A1 a_299_297# VPB sky130_fd_pr__pfet_01v8_hvt ad=0.14 pd=1.28 as=0.138 ps=1.27 w=1 l=0.15
X4 VGND a_81_21# X VNB sky130_fd_pr__nfet_01v8 ad=0.257 pd=1.44 as=0.169 ps=1.82 w=0.65 l=0.15
X5 VGND A2 a_384_47# VNB sky130_fd_pr__nfet_01v8 ad=0.172 pd=1.83 as=0.091 ps=0.93 w=0.65 l=0.15
X6 a_299_297# A2 VPWR VPB sky130_fd_pr__pfet_01v8_hvt ad=0.265 pd=2.53 as=0.14 ps=1.28 w=1 l=0.15
X7 a_384_47# A1 a_81_21# VNB sky130_fd_pr__nfet_01v8 ad=0.091 pd=0.93 as=0.0894 ps=0.925 w=0.65 l=0.15
.ends

.subckt sky130_fd_sc_hd__o211ai_1 VPB VNB VGND VPWR A1 Y C1 B1 A2
X0 a_110_297# A1 VPWR VPB sky130_fd_pr__pfet_01v8_hvt ad=0.105 pd=1.21 as=0.265 ps=2.53 w=1 l=0.15
X1 VGND A1 a_27_47# VNB sky130_fd_pr__nfet_01v8 ad=0.127 pd=1.04 as=0.172 ps=1.83 w=0.65 l=0.15
X2 Y A2 a_110_297# VPB sky130_fd_pr__pfet_01v8_hvt ad=0.195 pd=1.39 as=0.105 ps=1.21 w=1 l=0.15
X3 VPWR B1 Y VPB sky130_fd_pr__pfet_01v8_hvt ad=0.195 pd=1.39 as=0.195 ps=1.39 w=1 l=0.15
X4 a_27_47# A2 VGND VNB sky130_fd_pr__nfet_01v8 ad=0.127 pd=1.04 as=0.127 ps=1.04 w=0.65 l=0.15
X5 a_326_47# B1 a_27_47# VNB sky130_fd_pr__nfet_01v8 ad=0.0683 pd=0.86 as=0.127 ps=1.04 w=0.65 l=0.15
X6 Y C1 VPWR VPB sky130_fd_pr__pfet_01v8_hvt ad=0.635 pd=3.27 as=0.195 ps=1.39 w=1 l=0.15
X7 Y C1 a_326_47# VNB sky130_fd_pr__nfet_01v8 ad=0.393 pd=2.51 as=0.0683 ps=0.86 w=0.65 l=0.15
.ends

.subckt sky130_fd_sc_hd__o22ai_1 VPB VNB VGND VPWR A1 A2 B1 B2 Y
X0 VGND A2 a_27_47# VNB sky130_fd_pr__nfet_01v8 ad=0.0878 pd=0.92 as=0.115 ps=1 w=0.65 l=0.15
X1 a_27_47# B2 Y VNB sky130_fd_pr__nfet_01v8 ad=0.115 pd=1 as=0.0926 ps=0.935 w=0.65 l=0.15
X2 VPWR A1 a_307_297# VPB sky130_fd_pr__pfet_01v8_hvt ad=0.27 pd=2.54 as=0.105 ps=1.21 w=1 l=0.15
X3 a_307_297# A2 Y VPB sky130_fd_pr__pfet_01v8_hvt ad=0.105 pd=1.21 as=0.233 ps=1.47 w=1 l=0.15
X4 a_27_47# A1 VGND VNB sky130_fd_pr__nfet_01v8 ad=0.169 pd=1.82 as=0.0878 ps=0.92 w=0.65 l=0.15
X5 Y B2 a_109_297# VPB sky130_fd_pr__pfet_01v8_hvt ad=0.233 pd=1.47 as=0.112 ps=1.23 w=1 l=0.15
X6 a_109_297# B1 VPWR VPB sky130_fd_pr__pfet_01v8_hvt ad=0.112 pd=1.23 as=0.26 ps=2.52 w=1 l=0.15
X7 Y B1 a_27_47# VNB sky130_fd_pr__nfet_01v8 ad=0.0926 pd=0.935 as=0.169 ps=1.82 w=0.65 l=0.15
.ends

.subckt sky130_fd_sc_hd__mux2i_2 VNB VPB VPWR VGND S A0 A1 Y
X0 a_361_47# A0 Y VNB sky130_fd_pr__nfet_01v8 ad=0.0878 pd=0.92 as=0.169 ps=1.82 w=0.65 l=0.15
X1 Y A0 a_193_297# VPB sky130_fd_pr__pfet_01v8_hvt ad=0.155 pd=1.31 as=0.135 ps=1.27 w=1 l=0.15
X2 VPWR a_27_47# a_361_297# VPB sky130_fd_pr__pfet_01v8_hvt ad=0.26 pd=2.52 as=0.135 ps=1.27 w=1 l=0.15
X3 a_361_297# a_27_47# VPWR VPB sky130_fd_pr__pfet_01v8_hvt ad=0.135 pd=1.27 as=0.135 ps=1.27 w=1 l=0.15
X4 VPWR S a_193_297# VPB sky130_fd_pr__pfet_01v8_hvt ad=0.135 pd=1.27 as=0.135 ps=1.27 w=1 l=0.15
X5 Y A0 a_361_47# VNB sky130_fd_pr__nfet_01v8 ad=0.101 pd=0.96 as=0.0878 ps=0.92 w=0.65 l=0.15
X6 a_193_297# S VPWR VPB sky130_fd_pr__pfet_01v8_hvt ad=0.135 pd=1.27 as=0.135 ps=1.27 w=1 l=0.15
X7 a_361_297# A1 Y VPB sky130_fd_pr__pfet_01v8_hvt ad=0.138 pd=1.27 as=0.155 ps=1.31 w=1 l=0.15
X8 a_193_47# S VGND VNB sky130_fd_pr__nfet_01v8 ad=0.0878 pd=0.92 as=0.0878 ps=0.92 w=0.65 l=0.15
X9 a_361_47# a_27_47# VGND VNB sky130_fd_pr__nfet_01v8 ad=0.0878 pd=0.92 as=0.0878 ps=0.92 w=0.65 l=0.15
X10 a_193_297# A0 Y VPB sky130_fd_pr__pfet_01v8_hvt ad=0.135 pd=1.27 as=0.26 ps=2.52 w=1 l=0.15
X11 Y A1 a_361_297# VPB sky130_fd_pr__pfet_01v8_hvt ad=0.455 pd=2.91 as=0.138 ps=1.27 w=1 l=0.15
X12 Y A1 a_193_47# VNB sky130_fd_pr__nfet_01v8 ad=0.296 pd=2.21 as=0.0894 ps=0.925 w=0.65 l=0.15
X13 VGND S a_193_47# VNB sky130_fd_pr__nfet_01v8 ad=0.0878 pd=0.92 as=0.0878 ps=0.92 w=0.65 l=0.15
X14 VGND a_27_47# a_361_47# VNB sky130_fd_pr__nfet_01v8 ad=0.169 pd=1.82 as=0.0878 ps=0.92 w=0.65 l=0.15
X15 a_193_47# A1 Y VNB sky130_fd_pr__nfet_01v8 ad=0.0894 pd=0.925 as=0.101 ps=0.96 w=0.65 l=0.15
X16 VPWR S a_27_47# VPB sky130_fd_pr__pfet_01v8_hvt ad=0.135 pd=1.27 as=0.26 ps=2.52 w=1 l=0.15
X17 VGND S a_27_47# VNB sky130_fd_pr__nfet_01v8 ad=0.0878 pd=0.92 as=0.169 ps=1.82 w=0.65 l=0.15
.ends

.subckt sky130_fd_sc_hd__nand3_1 VPB VNB VGND VPWR A B Y C
X0 VPWR B Y VPB sky130_fd_pr__pfet_01v8_hvt ad=0.165 pd=1.33 as=0.135 ps=1.27 w=1 l=0.15
X1 Y A VPWR VPB sky130_fd_pr__pfet_01v8_hvt ad=0.26 pd=2.52 as=0.165 ps=1.33 w=1 l=0.15
X2 a_193_47# B a_109_47# VNB sky130_fd_pr__nfet_01v8 ad=0.107 pd=0.98 as=0.0878 ps=0.92 w=0.65 l=0.15
X3 Y A a_193_47# VNB sky130_fd_pr__nfet_01v8 ad=0.169 pd=1.82 as=0.107 ps=0.98 w=0.65 l=0.15
X4 Y C VPWR VPB sky130_fd_pr__pfet_01v8_hvt ad=0.135 pd=1.27 as=0.26 ps=2.52 w=1 l=0.15
X5 a_109_47# C VGND VNB sky130_fd_pr__nfet_01v8 ad=0.0878 pd=0.92 as=0.169 ps=1.82 w=0.65 l=0.15
.ends

.subckt sky130_fd_sc_hd__a21boi_1 VPWR VGND VPB VNB B1_N Y A1 A2
X0 a_300_297# a_27_413# Y VPB sky130_fd_pr__pfet_01v8_hvt ad=0.14 pd=1.28 as=0.265 ps=2.53 w=1 l=0.15
X1 VGND A2 a_384_47# VNB sky130_fd_pr__nfet_01v8 ad=0.172 pd=1.83 as=0.091 ps=0.93 w=0.65 l=0.15
X2 VPWR B1_N a_27_413# VPB sky130_fd_pr__pfet_01v8_hvt ad=0.111 pd=1.37 as=0.111 ps=1.37 w=0.42 l=0.15
X3 Y a_27_413# VGND VNB sky130_fd_pr__nfet_01v8 ad=0.143 pd=1.09 as=0.102 ps=0.99 w=0.65 l=0.15
X4 VPWR A1 a_300_297# VPB sky130_fd_pr__pfet_01v8_hvt ad=0.14 pd=1.28 as=0.14 ps=1.28 w=1 l=0.15
X5 a_384_47# A1 Y VNB sky130_fd_pr__nfet_01v8 ad=0.091 pd=0.93 as=0.143 ps=1.09 w=0.65 l=0.15
X6 VGND B1_N a_27_413# VNB sky130_fd_pr__nfet_01v8 ad=0.102 pd=0.99 as=0.111 ps=1.37 w=0.42 l=0.15
X7 a_300_297# A2 VPWR VPB sky130_fd_pr__pfet_01v8_hvt ad=0.265 pd=2.53 as=0.14 ps=1.28 w=1 l=0.15
.ends

.subckt sky130_fd_sc_hd__and4_1 X C A B D VGND VPWR VPB VNB
X0 a_27_47# C VPWR VPB sky130_fd_pr__pfet_01v8_hvt ad=0.0588 pd=0.7 as=0.0777 ps=0.79 w=0.42 l=0.15
X1 a_197_47# B a_109_47# VNB sky130_fd_pr__nfet_01v8 ad=0.0798 pd=0.8 as=0.0609 ps=0.71 w=0.42 l=0.15
X2 X a_27_47# VPWR VPB sky130_fd_pr__pfet_01v8_hvt ad=0.26 pd=2.52 as=0.312 ps=1.68 w=1 l=0.15
X3 a_303_47# C a_197_47# VNB sky130_fd_pr__nfet_01v8 ad=0.0693 pd=0.75 as=0.0798 ps=0.8 w=0.42 l=0.15
X4 a_27_47# A VPWR VPB sky130_fd_pr__pfet_01v8_hvt ad=0.0735 pd=0.77 as=0.109 ps=1.36 w=0.42 l=0.15
X5 VPWR D a_27_47# VPB sky130_fd_pr__pfet_01v8_hvt ad=0.312 pd=1.68 as=0.0588 ps=0.7 w=0.42 l=0.15
X6 VGND D a_303_47# VNB sky130_fd_pr__nfet_01v8 ad=0.196 pd=1.33 as=0.0693 ps=0.75 w=0.42 l=0.15
X7 VPWR B a_27_47# VPB sky130_fd_pr__pfet_01v8_hvt ad=0.0777 pd=0.79 as=0.0735 ps=0.77 w=0.42 l=0.15
X8 X a_27_47# VGND VNB sky130_fd_pr__nfet_01v8 ad=0.169 pd=1.82 as=0.196 ps=1.33 w=0.65 l=0.15
X9 a_109_47# A a_27_47# VNB sky130_fd_pr__nfet_01v8 ad=0.0609 pd=0.71 as=0.109 ps=1.36 w=0.42 l=0.15
.ends

.subckt sky130_fd_sc_hd__and4_2 VNB VPB VGND VPWR X D C B A
X0 VGND a_27_47# X VNB sky130_fd_pr__nfet_01v8 ad=0.195 pd=1.9 as=0.107 ps=0.98 w=0.65 l=0.15
X1 VGND D a_304_47# VNB sky130_fd_pr__nfet_01v8 ad=0.175 pd=1.26 as=0.0693 ps=0.75 w=0.42 l=0.15
X2 X a_27_47# VPWR VPB sky130_fd_pr__pfet_01v8_hvt ad=0.165 pd=1.33 as=0.28 ps=1.62 w=1 l=0.15
X3 a_198_47# B a_109_47# VNB sky130_fd_pr__nfet_01v8 ad=0.0798 pd=0.8 as=0.0619 ps=0.715 w=0.42 l=0.15
X4 a_27_47# C VPWR VPB sky130_fd_pr__pfet_01v8_hvt ad=0.0588 pd=0.7 as=0.0777 ps=0.79 w=0.42 l=0.15
X5 VPWR a_27_47# X VPB sky130_fd_pr__pfet_01v8_hvt ad=0.3 pd=2.6 as=0.165 ps=1.33 w=1 l=0.15
X6 a_304_47# C a_198_47# VNB sky130_fd_pr__nfet_01v8 ad=0.0693 pd=0.75 as=0.0798 ps=0.8 w=0.42 l=0.15
X7 a_27_47# A VPWR VPB sky130_fd_pr__pfet_01v8_hvt ad=0.0746 pd=0.775 as=0.109 ps=1.36 w=0.42 l=0.15
X8 VPWR D a_27_47# VPB sky130_fd_pr__pfet_01v8_hvt ad=0.28 pd=1.62 as=0.0588 ps=0.7 w=0.42 l=0.15
X9 X a_27_47# VGND VNB sky130_fd_pr__nfet_01v8 ad=0.107 pd=0.98 as=0.175 ps=1.26 w=0.65 l=0.15
X10 VPWR B a_27_47# VPB sky130_fd_pr__pfet_01v8_hvt ad=0.0777 pd=0.79 as=0.0746 ps=0.775 w=0.42 l=0.15
X11 a_109_47# A a_27_47# VNB sky130_fd_pr__nfet_01v8 ad=0.0619 pd=0.715 as=0.109 ps=1.36 w=0.42 l=0.15
.ends

.subckt sky130_fd_sc_hd__mux2_1 VGND VPWR VPB VNB X A1 S A0
X0 VPWR a_505_21# a_535_374# VPB sky130_fd_pr__pfet_01v8_hvt ad=0.0693 pd=0.75 as=0.0441 ps=0.63 w=0.42 l=0.15
X1 a_505_21# S VPWR VPB sky130_fd_pr__pfet_01v8_hvt ad=0.118 pd=1.4 as=0.0693 ps=0.75 w=0.42 l=0.15
X2 a_218_374# S VPWR VPB sky130_fd_pr__pfet_01v8_hvt ad=0.0767 pd=0.785 as=0.158 ps=1.39 w=0.42 l=0.15
X3 VGND a_505_21# a_439_47# VNB sky130_fd_pr__nfet_01v8 ad=0.145 pd=1.11 as=0.0693 ps=0.75 w=0.42 l=0.15
X4 a_76_199# A0 a_218_374# VPB sky130_fd_pr__pfet_01v8_hvt ad=0.193 pd=1.34 as=0.0767 ps=0.785 w=0.42 l=0.15
X5 a_505_21# S VGND VNB sky130_fd_pr__nfet_01v8 ad=0.109 pd=1.36 as=0.145 ps=1.11 w=0.42 l=0.15
X6 a_439_47# A0 a_76_199# VNB sky130_fd_pr__nfet_01v8 ad=0.0693 pd=0.75 as=0.0997 ps=0.895 w=0.42 l=0.15
X7 a_535_374# A1 a_76_199# VPB sky130_fd_pr__pfet_01v8_hvt ad=0.0441 pd=0.63 as=0.193 ps=1.34 w=0.42 l=0.15
X8 a_76_199# A1 a_218_47# VNB sky130_fd_pr__nfet_01v8 ad=0.0997 pd=0.895 as=0.0693 ps=0.75 w=0.42 l=0.15
X9 a_218_47# S VGND VNB sky130_fd_pr__nfet_01v8 ad=0.0693 pd=0.75 as=0.113 ps=1.04 w=0.42 l=0.15
X10 VPWR a_76_199# X VPB sky130_fd_pr__pfet_01v8_hvt ad=0.158 pd=1.39 as=0.26 ps=2.52 w=1 l=0.15
X11 VGND a_76_199# X VNB sky130_fd_pr__nfet_01v8 ad=0.113 pd=1.04 as=0.169 ps=1.82 w=0.65 l=0.15
.ends

.subckt sky130_fd_sc_hd__and2_2 VPWR VGND A X B VPB VNB
X0 X a_61_75# VPWR VPB sky130_fd_pr__pfet_01v8_hvt ad=0.195 pd=1.39 as=0.167 ps=1.39 w=1 l=0.15
X1 VPWR a_61_75# X VPB sky130_fd_pr__pfet_01v8_hvt ad=0.38 pd=2.76 as=0.195 ps=1.39 w=1 l=0.15
X2 VPWR B a_61_75# VPB sky130_fd_pr__pfet_01v8_hvt ad=0.167 pd=1.39 as=0.0567 ps=0.69 w=0.42 l=0.15
X3 VGND B a_147_75# VNB sky130_fd_pr__nfet_01v8 ad=0.112 pd=1.04 as=0.0567 ps=0.69 w=0.42 l=0.15
X4 X a_61_75# VGND VNB sky130_fd_pr__nfet_01v8 ad=0.127 pd=1.04 as=0.112 ps=1.04 w=0.65 l=0.15
X5 VGND a_61_75# X VNB sky130_fd_pr__nfet_01v8 ad=0.247 pd=2.06 as=0.127 ps=1.04 w=0.65 l=0.15
X6 a_61_75# A VPWR VPB sky130_fd_pr__pfet_01v8_hvt ad=0.0567 pd=0.69 as=0.118 ps=1.4 w=0.42 l=0.15
X7 a_147_75# A a_61_75# VNB sky130_fd_pr__nfet_01v8 ad=0.0567 pd=0.69 as=0.118 ps=1.4 w=0.42 l=0.15
.ends

.subckt sky130_fd_sc_hd__nor3b_1 VPB VNB VGND VPWR C_N B Y A
X0 VGND a_91_199# Y VNB sky130_fd_pr__nfet_01v8 ad=0.0878 pd=0.92 as=0.221 ps=1.98 w=0.65 l=0.15
X1 Y B VGND VNB sky130_fd_pr__nfet_01v8 ad=0.0878 pd=0.92 as=0.0878 ps=0.92 w=0.65 l=0.15
X2 VPWR A a_245_297# VPB sky130_fd_pr__pfet_01v8_hvt ad=0.146 pd=1.34 as=0.135 ps=1.27 w=1 l=0.15
X3 a_91_199# C_N VGND VNB sky130_fd_pr__nfet_01v8 ad=0.109 pd=1.36 as=0.1 ps=0.985 w=0.42 l=0.15
X4 VGND A Y VNB sky130_fd_pr__nfet_01v8 ad=0.1 pd=0.985 as=0.0878 ps=0.92 w=0.65 l=0.15
X5 a_245_297# B a_161_297# VPB sky130_fd_pr__pfet_01v8_hvt ad=0.135 pd=1.27 as=0.135 ps=1.27 w=1 l=0.15
X6 a_91_199# C_N VPWR VPB sky130_fd_pr__pfet_01v8_hvt ad=0.109 pd=1.36 as=0.146 ps=1.34 w=0.42 l=0.15
X7 a_161_297# a_91_199# Y VPB sky130_fd_pr__pfet_01v8_hvt ad=0.135 pd=1.27 as=0.32 ps=2.64 w=1 l=0.15
.ends

.subckt sky130_fd_sc_hd__nand4b_1 VPB VNB VGND VPWR Y C B D A_N
X0 Y B VPWR VPB sky130_fd_pr__pfet_01v8_hvt ad=0.195 pd=1.39 as=0.192 ps=1.38 w=1 l=0.15
X1 a_232_47# D VGND VNB sky130_fd_pr__nfet_01v8 ad=0.0878 pd=0.92 as=0.118 ps=1.04 w=0.65 l=0.15
X2 VPWR C Y VPB sky130_fd_pr__pfet_01v8_hvt ad=0.192 pd=1.38 as=0.135 ps=1.27 w=1 l=0.15
X3 VPWR A_N a_41_93# VPB sky130_fd_pr__pfet_01v8_hvt ad=0.146 pd=1.34 as=0.109 ps=1.36 w=0.42 l=0.15
X4 VPWR a_41_93# Y VPB sky130_fd_pr__pfet_01v8_hvt ad=0.28 pd=2.56 as=0.195 ps=1.39 w=1 l=0.15
X5 a_316_47# C a_232_47# VNB sky130_fd_pr__nfet_01v8 ad=0.125 pd=1.03 as=0.0878 ps=0.92 w=0.65 l=0.15
X6 Y a_41_93# a_423_47# VNB sky130_fd_pr__nfet_01v8 ad=0.228 pd=2 as=0.127 ps=1.04 w=0.65 l=0.15
X7 a_423_47# B a_316_47# VNB sky130_fd_pr__nfet_01v8 ad=0.127 pd=1.04 as=0.125 ps=1.03 w=0.65 l=0.15
X8 Y D VPWR VPB sky130_fd_pr__pfet_01v8_hvt ad=0.135 pd=1.27 as=0.146 ps=1.34 w=1 l=0.15
X9 VGND A_N a_41_93# VNB sky130_fd_pr__nfet_01v8 ad=0.118 pd=1.04 as=0.111 ps=1.37 w=0.42 l=0.15
.ends

.subckt sky130_fd_sc_hd__nor2_2 VPB VNB VGND VPWR B Y A
X0 Y B a_27_297# VPB sky130_fd_pr__pfet_01v8_hvt ad=0.135 pd=1.27 as=0.135 ps=1.27 w=1 l=0.15
X1 Y B VGND VNB sky130_fd_pr__nfet_01v8 ad=0.0878 pd=0.92 as=0.0878 ps=0.92 w=0.65 l=0.15
X2 a_27_297# A VPWR VPB sky130_fd_pr__pfet_01v8_hvt ad=0.135 pd=1.27 as=0.135 ps=1.27 w=1 l=0.15
X3 VGND A Y VNB sky130_fd_pr__nfet_01v8 ad=0.0878 pd=0.92 as=0.0878 ps=0.92 w=0.65 l=0.15
X4 Y A VGND VNB sky130_fd_pr__nfet_01v8 ad=0.0878 pd=0.92 as=0.182 ps=1.86 w=0.65 l=0.15
X5 VGND B Y VNB sky130_fd_pr__nfet_01v8 ad=0.169 pd=1.82 as=0.0878 ps=0.92 w=0.65 l=0.15
X6 VPWR A a_27_297# VPB sky130_fd_pr__pfet_01v8_hvt ad=0.135 pd=1.27 as=0.28 ps=2.56 w=1 l=0.15
X7 a_27_297# B Y VPB sky130_fd_pr__pfet_01v8_hvt ad=0.26 pd=2.52 as=0.135 ps=1.27 w=1 l=0.15
.ends

.subckt sky130_fd_sc_hd__and2_1 VPWR VGND X B A VPB VNB
X0 VPWR B a_59_75# VPB sky130_fd_pr__pfet_01v8_hvt ad=0.167 pd=1.39 as=0.0567 ps=0.69 w=0.42 l=0.15
X1 X a_59_75# VPWR VPB sky130_fd_pr__pfet_01v8_hvt ad=0.475 pd=2.95 as=0.167 ps=1.39 w=1 l=0.15
X2 VGND B a_145_75# VNB sky130_fd_pr__nfet_01v8 ad=0.112 pd=1.04 as=0.0567 ps=0.69 w=0.42 l=0.15
X3 a_59_75# A VPWR VPB sky130_fd_pr__pfet_01v8_hvt ad=0.0567 pd=0.69 as=0.118 ps=1.4 w=0.42 l=0.15
X4 X a_59_75# VGND VNB sky130_fd_pr__nfet_01v8 ad=0.182 pd=1.86 as=0.112 ps=1.04 w=0.65 l=0.15
X5 a_145_75# A a_59_75# VNB sky130_fd_pr__nfet_01v8 ad=0.0567 pd=0.69 as=0.118 ps=1.4 w=0.42 l=0.15
.ends

.subckt sky130_fd_sc_hd__o32ai_1 VPB VNB VGND VPWR A1 A2 B1 Y B2 A3
X0 VGND A3 a_27_47# VNB sky130_fd_pr__nfet_01v8 ad=0.219 pd=1.33 as=0.101 ps=0.96 w=0.65 l=0.15
X1 a_27_47# A2 VGND VNB sky130_fd_pr__nfet_01v8 ad=0.0878 pd=0.92 as=0.219 ps=1.33 w=0.65 l=0.15
X2 Y B2 a_109_297# VPB sky130_fd_pr__pfet_01v8_hvt ad=0.305 pd=1.61 as=0.105 ps=1.21 w=1 l=0.15
X3 a_333_297# A3 Y VPB sky130_fd_pr__pfet_01v8_hvt ad=0.245 pd=1.49 as=0.305 ps=1.61 w=1 l=0.15
X4 VGND A1 a_27_47# VNB sky130_fd_pr__nfet_01v8 ad=0.234 pd=2.02 as=0.0878 ps=0.92 w=0.65 l=0.15
X5 a_27_47# B2 Y VNB sky130_fd_pr__nfet_01v8 ad=0.101 pd=0.96 as=0.106 ps=0.975 w=0.65 l=0.15
X6 VPWR A1 a_461_297# VPB sky130_fd_pr__pfet_01v8_hvt ad=0.28 pd=2.56 as=0.135 ps=1.27 w=1 l=0.15
X7 a_109_297# B1 VPWR VPB sky130_fd_pr__pfet_01v8_hvt ad=0.105 pd=1.21 as=0.26 ps=2.52 w=1 l=0.15
X8 a_461_297# A2 a_333_297# VPB sky130_fd_pr__pfet_01v8_hvt ad=0.135 pd=1.27 as=0.245 ps=1.49 w=1 l=0.15
X9 Y B1 a_27_47# VNB sky130_fd_pr__nfet_01v8 ad=0.106 pd=0.975 as=0.169 ps=1.82 w=0.65 l=0.15
.ends

.subckt sky130_fd_sc_hd__o221ai_2 VNB VPB VGND VPWR Y B1 B2 A2 A1 C1
X0 Y A2 a_734_297# VPB sky130_fd_pr__pfet_01v8_hvt ad=0.135 pd=1.27 as=0.135 ps=1.27 w=1 l=0.15
X1 a_300_47# B2 a_28_47# VNB sky130_fd_pr__nfet_01v8 ad=0.0878 pd=0.92 as=0.0878 ps=0.92 w=0.65 l=0.15
X2 Y C1 VPWR VPB sky130_fd_pr__pfet_01v8_hvt ad=0.135 pd=1.27 as=0.26 ps=2.52 w=1 l=0.15
X3 a_300_47# B1 a_28_47# VNB sky130_fd_pr__nfet_01v8 ad=0.114 pd=1 as=0.0878 ps=0.92 w=0.65 l=0.15
X4 a_300_47# A2 VGND VNB sky130_fd_pr__nfet_01v8 ad=0.0878 pd=0.92 as=0.0878 ps=0.92 w=0.65 l=0.15
X5 a_300_47# A1 VGND VNB sky130_fd_pr__nfet_01v8 ad=0.169 pd=1.82 as=0.0878 ps=0.92 w=0.65 l=0.15
X6 a_734_297# A1 VPWR VPB sky130_fd_pr__pfet_01v8_hvt ad=0.135 pd=1.27 as=0.175 ps=1.35 w=1 l=0.15
X7 a_28_47# C1 Y VNB sky130_fd_pr__nfet_01v8 ad=0.169 pd=1.82 as=0.0878 ps=0.92 w=0.65 l=0.15
X8 Y C1 a_28_47# VNB sky130_fd_pr__nfet_01v8 ad=0.0878 pd=0.92 as=0.169 ps=1.82 w=0.65 l=0.15
X9 VPWR C1 Y VPB sky130_fd_pr__pfet_01v8_hvt ad=0.395 pd=1.79 as=0.135 ps=1.27 w=1 l=0.15
X10 VPWR B1 a_382_297# VPB sky130_fd_pr__pfet_01v8_hvt ad=0.175 pd=1.35 as=0.135 ps=1.27 w=1 l=0.15
X11 a_382_297# B2 Y VPB sky130_fd_pr__pfet_01v8_hvt ad=0.135 pd=1.27 as=0.135 ps=1.27 w=1 l=0.15
X12 a_28_47# B1 a_300_47# VNB sky130_fd_pr__nfet_01v8 ad=0.0878 pd=0.92 as=0.169 ps=1.82 w=0.65 l=0.15
X13 a_28_47# B2 a_300_47# VNB sky130_fd_pr__nfet_01v8 ad=0.0878 pd=0.92 as=0.0878 ps=0.92 w=0.65 l=0.15
X14 VGND A1 a_300_47# VNB sky130_fd_pr__nfet_01v8 ad=0.0878 pd=0.92 as=0.114 ps=1 w=0.65 l=0.15
X15 Y B2 a_382_297# VPB sky130_fd_pr__pfet_01v8_hvt ad=0.135 pd=1.27 as=0.135 ps=1.27 w=1 l=0.15
X16 VPWR A1 a_734_297# VPB sky130_fd_pr__pfet_01v8_hvt ad=0.285 pd=2.57 as=0.135 ps=1.27 w=1 l=0.15
X17 VGND A2 a_300_47# VNB sky130_fd_pr__nfet_01v8 ad=0.0878 pd=0.92 as=0.0878 ps=0.92 w=0.65 l=0.15
X18 a_382_297# B1 VPWR VPB sky130_fd_pr__pfet_01v8_hvt ad=0.135 pd=1.27 as=0.395 ps=1.79 w=1 l=0.15
X19 a_734_297# A2 Y VPB sky130_fd_pr__pfet_01v8_hvt ad=0.135 pd=1.27 as=0.135 ps=1.27 w=1 l=0.15
.ends

.subckt sky130_fd_sc_hd__o21ai_0 VNB VPB VGND VPWR B1 A1 Y A2
X0 a_120_369# A1 VPWR VPB sky130_fd_pr__pfet_01v8_hvt ad=0.0768 pd=0.88 as=0.17 ps=1.81 w=0.64 l=0.15
X1 VGND A1 a_32_47# VNB sky130_fd_pr__nfet_01v8 ad=0.0588 pd=0.7 as=0.111 ps=1.37 w=0.42 l=0.15
X2 Y A2 a_120_369# VPB sky130_fd_pr__pfet_01v8_hvt ad=0.0896 pd=0.92 as=0.0768 ps=0.88 w=0.64 l=0.15
X3 a_32_47# A2 VGND VNB sky130_fd_pr__nfet_01v8 ad=0.0588 pd=0.7 as=0.0588 ps=0.7 w=0.42 l=0.15
X4 VPWR B1 Y VPB sky130_fd_pr__pfet_01v8_hvt ad=0.182 pd=1.85 as=0.0896 ps=0.92 w=0.64 l=0.15
X5 Y B1 a_32_47# VNB sky130_fd_pr__nfet_01v8 ad=0.111 pd=1.37 as=0.0588 ps=0.7 w=0.42 l=0.15
.ends

.subckt sky130_fd_sc_hd__a22o_2 VPWR VGND VPB VNB B2 B1 A1 A2 X
X0 VPWR a_27_297# X VPB sky130_fd_pr__pfet_01v8_hvt ad=0.27 pd=2.54 as=0.135 ps=1.27 w=1 l=0.15
X1 VGND A2 a_381_47# VNB sky130_fd_pr__nfet_01v8 ad=0.102 pd=0.965 as=0.107 ps=0.98 w=0.65 l=0.15
X2 X a_27_297# VGND VNB sky130_fd_pr__nfet_01v8 ad=0.0878 pd=0.92 as=0.102 ps=0.965 w=0.65 l=0.15
X3 X a_27_297# VPWR VPB sky130_fd_pr__pfet_01v8_hvt ad=0.135 pd=1.27 as=0.157 ps=1.32 w=1 l=0.15
X4 a_27_297# B1 a_109_47# VNB sky130_fd_pr__nfet_01v8 ad=0.169 pd=1.82 as=0.0747 ps=0.88 w=0.65 l=0.15
X5 a_27_297# B1 a_109_297# VPB sky130_fd_pr__pfet_01v8_hvt ad=0.26 pd=2.52 as=0.135 ps=1.27 w=1 l=0.15
X6 VGND a_27_297# X VNB sky130_fd_pr__nfet_01v8 ad=0.176 pd=1.84 as=0.0878 ps=0.92 w=0.65 l=0.15
X7 a_109_297# A1 VPWR VPB sky130_fd_pr__pfet_01v8_hvt ad=0.165 pd=1.33 as=0.26 ps=2.52 w=1 l=0.15
X8 VPWR A2 a_109_297# VPB sky130_fd_pr__pfet_01v8_hvt ad=0.157 pd=1.32 as=0.165 ps=1.33 w=1 l=0.15
X9 a_381_47# A1 a_27_297# VNB sky130_fd_pr__nfet_01v8 ad=0.107 pd=0.98 as=0.169 ps=1.82 w=0.65 l=0.15
X10 a_109_297# B2 a_27_297# VPB sky130_fd_pr__pfet_01v8_hvt ad=0.135 pd=1.27 as=0.26 ps=2.52 w=1 l=0.15
X11 a_109_47# B2 VGND VNB sky130_fd_pr__nfet_01v8 ad=0.0747 pd=0.88 as=0.169 ps=1.82 w=0.65 l=0.15
.ends

.subckt sky130_fd_sc_hd__clkbuf_8 X A VPB VNB VGND VPWR
X0 VPWR A a_110_47# VPB sky130_fd_pr__pfet_01v8_hvt ad=0.14 pd=1.28 as=0.14 ps=1.28 w=1 l=0.15
X1 VPWR a_110_47# X VPB sky130_fd_pr__pfet_01v8_hvt ad=0.14 pd=1.28 as=0.14 ps=1.28 w=1 l=0.15
X2 X a_110_47# VPWR VPB sky130_fd_pr__pfet_01v8_hvt ad=0.14 pd=1.28 as=0.14 ps=1.28 w=1 l=0.15
X3 a_110_47# A VPWR VPB sky130_fd_pr__pfet_01v8_hvt ad=0.14 pd=1.28 as=0.265 ps=2.53 w=1 l=0.15
X4 X a_110_47# VGND VNB sky130_fd_pr__nfet_01v8 ad=0.0588 pd=0.7 as=0.0588 ps=0.7 w=0.42 l=0.15
X5 X a_110_47# VPWR VPB sky130_fd_pr__pfet_01v8_hvt ad=0.14 pd=1.28 as=0.14 ps=1.28 w=1 l=0.15
X6 VGND a_110_47# X VNB sky130_fd_pr__nfet_01v8 ad=0.0588 pd=0.7 as=0.0588 ps=0.7 w=0.42 l=0.15
X7 VPWR a_110_47# X VPB sky130_fd_pr__pfet_01v8_hvt ad=0.14 pd=1.28 as=0.14 ps=1.28 w=1 l=0.15
X8 VGND A a_110_47# VNB sky130_fd_pr__nfet_01v8 ad=0.0588 pd=0.7 as=0.0588 ps=0.7 w=0.42 l=0.15
X9 VGND a_110_47# X VNB sky130_fd_pr__nfet_01v8 ad=0.113 pd=1.38 as=0.0588 ps=0.7 w=0.42 l=0.15
X10 a_110_47# A VGND VNB sky130_fd_pr__nfet_01v8 ad=0.0588 pd=0.7 as=0.111 ps=1.37 w=0.42 l=0.15
X11 VPWR a_110_47# X VPB sky130_fd_pr__pfet_01v8_hvt ad=0.14 pd=1.28 as=0.14 ps=1.28 w=1 l=0.15
X12 X a_110_47# VPWR VPB sky130_fd_pr__pfet_01v8_hvt ad=0.14 pd=1.28 as=0.14 ps=1.28 w=1 l=0.15
X13 VGND a_110_47# X VNB sky130_fd_pr__nfet_01v8 ad=0.0588 pd=0.7 as=0.0588 ps=0.7 w=0.42 l=0.15
X14 VGND a_110_47# X VNB sky130_fd_pr__nfet_01v8 ad=0.0588 pd=0.7 as=0.0588 ps=0.7 w=0.42 l=0.15
X15 X a_110_47# VPWR VPB sky130_fd_pr__pfet_01v8_hvt ad=0.14 pd=1.28 as=0.14 ps=1.28 w=1 l=0.15
X16 X a_110_47# VGND VNB sky130_fd_pr__nfet_01v8 ad=0.0588 pd=0.7 as=0.0588 ps=0.7 w=0.42 l=0.15
X17 VPWR a_110_47# X VPB sky130_fd_pr__pfet_01v8_hvt ad=0.265 pd=2.53 as=0.14 ps=1.28 w=1 l=0.15
X18 X a_110_47# VGND VNB sky130_fd_pr__nfet_01v8 ad=0.0588 pd=0.7 as=0.0588 ps=0.7 w=0.42 l=0.15
X19 X a_110_47# VGND VNB sky130_fd_pr__nfet_01v8 ad=0.0588 pd=0.7 as=0.0588 ps=0.7 w=0.42 l=0.15
.ends

.subckt sky130_fd_sc_hd__lpflow_inputiso1p_1 VPB VNB VGND VPWR X SLEEP A
X0 VGND SLEEP a_68_297# VNB sky130_fd_pr__nfet_01v8 ad=0.1 pd=0.985 as=0.0567 ps=0.69 w=0.42 l=0.15
X1 a_68_297# A VGND VNB sky130_fd_pr__nfet_01v8 ad=0.0567 pd=0.69 as=0.109 ps=1.36 w=0.42 l=0.15
X2 X a_68_297# VGND VNB sky130_fd_pr__nfet_01v8 ad=0.169 pd=1.82 as=0.1 ps=0.985 w=0.65 l=0.15
X3 VPWR SLEEP a_150_297# VPB sky130_fd_pr__pfet_01v8_hvt ad=0.146 pd=1.34 as=0.0441 ps=0.63 w=0.42 l=0.15
X4 X a_68_297# VPWR VPB sky130_fd_pr__pfet_01v8_hvt ad=0.34 pd=2.68 as=0.146 ps=1.34 w=1 l=0.15
X5 a_150_297# A a_68_297# VPB sky130_fd_pr__pfet_01v8_hvt ad=0.0441 pd=0.63 as=0.109 ps=1.36 w=0.42 l=0.15
.ends

.subckt sky130_fd_sc_hd__o21ai_1 VGND VPWR A2 B1 Y A1 VPB VNB
X0 Y A2 a_109_297# VPB sky130_fd_pr__pfet_01v8_hvt ad=0.174 pd=1.39 as=0.105 ps=1.21 w=1 l=0.15
X1 VPWR B1 Y VPB sky130_fd_pr__pfet_01v8_hvt ad=0.182 pd=1.92 as=0.174 ps=1.39 w=0.7 l=0.15
X2 a_27_47# A2 VGND VNB sky130_fd_pr__nfet_01v8 ad=0.0878 pd=0.92 as=0.107 ps=0.98 w=0.65 l=0.15
X3 Y B1 a_27_47# VNB sky130_fd_pr__nfet_01v8 ad=0.169 pd=1.82 as=0.0878 ps=0.92 w=0.65 l=0.15
X4 a_109_297# A1 VPWR VPB sky130_fd_pr__pfet_01v8_hvt ad=0.105 pd=1.21 as=0.26 ps=2.52 w=1 l=0.15
X5 VGND A1 a_27_47# VNB sky130_fd_pr__nfet_01v8 ad=0.107 pd=0.98 as=0.169 ps=1.82 w=0.65 l=0.15
.ends

.subckt sky130_fd_sc_hd__o21a_1 VPB VNB VGND VPWR A1 A2 B1 X
X0 VPWR A1 a_382_297# VPB sky130_fd_pr__pfet_01v8_hvt ad=0.26 pd=2.52 as=0.153 ps=1.3 w=1 l=0.15
X1 a_297_47# B1 a_79_21# VNB sky130_fd_pr__nfet_01v8 ad=0.101 pd=0.96 as=0.169 ps=1.82 w=0.65 l=0.15
X2 a_297_47# A1 VGND VNB sky130_fd_pr__nfet_01v8 ad=0.169 pd=1.82 as=0.0878 ps=0.92 w=0.65 l=0.15
X3 VGND A2 a_297_47# VNB sky130_fd_pr__nfet_01v8 ad=0.0878 pd=0.92 as=0.101 ps=0.96 w=0.65 l=0.15
X4 VPWR a_79_21# X VPB sky130_fd_pr__pfet_01v8_hvt ad=0.327 pd=1.65 as=0.28 ps=2.56 w=1 l=0.15
X5 a_79_21# B1 VPWR VPB sky130_fd_pr__pfet_01v8_hvt ad=0.195 pd=1.39 as=0.327 ps=1.65 w=1 l=0.15
X6 a_382_297# A2 a_79_21# VPB sky130_fd_pr__pfet_01v8_hvt ad=0.153 pd=1.3 as=0.195 ps=1.39 w=1 l=0.15
X7 VGND a_79_21# X VNB sky130_fd_pr__nfet_01v8 ad=0.169 pd=1.82 as=0.169 ps=1.82 w=0.65 l=0.15
.ends

.subckt sky130_fd_sc_hd__buf_6 VPWR VGND X A VPB VNB
X0 VPWR a_161_47# X VPB sky130_fd_pr__pfet_01v8_hvt ad=0.26 pd=2.52 as=0.135 ps=1.27 w=1 l=0.15
X1 a_161_47# A VGND VNB sky130_fd_pr__nfet_01v8 ad=0.0878 pd=0.92 as=0.169 ps=1.82 w=0.65 l=0.15
X2 X a_161_47# VPWR VPB sky130_fd_pr__pfet_01v8_hvt ad=0.135 pd=1.27 as=0.135 ps=1.27 w=1 l=0.15
X3 VPWR a_161_47# X VPB sky130_fd_pr__pfet_01v8_hvt ad=0.135 pd=1.27 as=0.135 ps=1.27 w=1 l=0.15
X4 VGND A a_161_47# VNB sky130_fd_pr__nfet_01v8 ad=0.0878 pd=0.92 as=0.0878 ps=0.92 w=0.65 l=0.15
X5 X a_161_47# VPWR VPB sky130_fd_pr__pfet_01v8_hvt ad=0.135 pd=1.27 as=0.135 ps=1.27 w=1 l=0.15
X6 VGND a_161_47# X VNB sky130_fd_pr__nfet_01v8 ad=0.0878 pd=0.92 as=0.0878 ps=0.92 w=0.65 l=0.15
X7 VGND a_161_47# X VNB sky130_fd_pr__nfet_01v8 ad=0.0878 pd=0.92 as=0.0878 ps=0.92 w=0.65 l=0.15
X8 VPWR a_161_47# X VPB sky130_fd_pr__pfet_01v8_hvt ad=0.135 pd=1.27 as=0.135 ps=1.27 w=1 l=0.15
X9 X a_161_47# VPWR VPB sky130_fd_pr__pfet_01v8_hvt ad=0.135 pd=1.27 as=0.135 ps=1.27 w=1 l=0.15
X10 X a_161_47# VGND VNB sky130_fd_pr__nfet_01v8 ad=0.0878 pd=0.92 as=0.0878 ps=0.92 w=0.65 l=0.15
X11 X a_161_47# VGND VNB sky130_fd_pr__nfet_01v8 ad=0.0878 pd=0.92 as=0.0878 ps=0.92 w=0.65 l=0.15
X12 X a_161_47# VGND VNB sky130_fd_pr__nfet_01v8 ad=0.0878 pd=0.92 as=0.0878 ps=0.92 w=0.65 l=0.15
X13 VPWR A a_161_47# VPB sky130_fd_pr__pfet_01v8_hvt ad=0.135 pd=1.27 as=0.135 ps=1.27 w=1 l=0.15
X14 VGND a_161_47# X VNB sky130_fd_pr__nfet_01v8 ad=0.169 pd=1.82 as=0.0878 ps=0.92 w=0.65 l=0.15
X15 a_161_47# A VPWR VPB sky130_fd_pr__pfet_01v8_hvt ad=0.135 pd=1.27 as=0.26 ps=2.52 w=1 l=0.15
.ends

.subckt sky130_fd_sc_hd__dfstp_1 VPB VNB VPWR VGND Q SET_B D CLK
X0 VGND a_652_21# a_586_47# VNB sky130_fd_pr__nfet_01v8 ad=0.0882 pd=0.84 as=0.0671 ps=0.75 w=0.42 l=0.15
X1 a_956_413# a_476_47# VPWR VPB sky130_fd_pr__pfet_01v8_hvt ad=0.0483 pd=0.65 as=0.0567 ps=0.69 w=0.42 l=0.15
X2 VPWR a_476_47# a_652_21# VPB sky130_fd_pr__pfet_01v8_hvt ad=0.0567 pd=0.69 as=0.0567 ps=0.69 w=0.42 l=0.15
X3 VPWR CLK a_27_47# VPB sky130_fd_pr__pfet_01v8_hvt ad=0.0864 pd=0.91 as=0.166 ps=1.8 w=0.64 l=0.15
X4 a_586_47# a_193_47# a_476_47# VNB sky130_fd_pr__special_nfet_01v8 ad=0.0671 pd=0.75 as=0.072 ps=0.76 w=0.36 l=0.15
X5 a_1056_47# a_476_47# VGND VNB sky130_fd_pr__nfet_01v8 ad=0.0441 pd=0.63 as=0.109 ps=1.36 w=0.42 l=0.15
X6 a_476_47# a_27_47# a_381_47# VNB sky130_fd_pr__special_nfet_01v8 ad=0.072 pd=0.76 as=0.0935 ps=0.965 w=0.36 l=0.15
X7 a_381_47# D VPWR VPB sky130_fd_pr__pfet_01v8_hvt ad=0.125 pd=1.17 as=0.218 ps=2.2 w=0.84 l=0.15
X8 a_652_21# SET_B VPWR VPB sky130_fd_pr__pfet_01v8_hvt ad=0.0567 pd=0.69 as=0.0798 ps=0.8 w=0.42 l=0.15
X9 a_1224_47# a_27_47# a_1032_413# VNB sky130_fd_pr__nfet_01v8 ad=0.0441 pd=0.63 as=0.0693 ps=0.75 w=0.42 l=0.15
X10 a_562_413# a_27_47# a_476_47# VPB sky130_fd_pr__pfet_01v8_hvt ad=0.0945 pd=0.87 as=0.0567 ps=0.69 w=0.42 l=0.15
X11 VGND a_1032_413# a_1602_47# VNB sky130_fd_pr__nfet_01v8 ad=0.097 pd=0.975 as=0.109 ps=1.36 w=0.42 l=0.15
X12 VPWR a_1182_261# a_1140_413# VPB sky130_fd_pr__pfet_01v8_hvt ad=0.109 pd=1.36 as=0.0441 ps=0.63 w=0.42 l=0.15
X13 Q a_1602_47# VPWR VPB sky130_fd_pr__pfet_01v8_hvt ad=0.26 pd=2.52 as=0.149 ps=1.33 w=1 l=0.15
X14 a_1032_413# a_193_47# a_1056_47# VNB sky130_fd_pr__nfet_01v8 ad=0.0693 pd=0.75 as=0.0441 ps=0.63 w=0.42 l=0.15
X15 a_476_47# a_193_47# a_381_47# VPB sky130_fd_pr__pfet_01v8_hvt ad=0.0567 pd=0.69 as=0.125 ps=1.17 w=0.42 l=0.15
X16 a_1296_47# a_1182_261# a_1224_47# VNB sky130_fd_pr__nfet_01v8 ad=0.0483 pd=0.65 as=0.0441 ps=0.63 w=0.42 l=0.15
X17 a_193_47# a_27_47# VGND VNB sky130_fd_pr__nfet_01v8 ad=0.109 pd=1.36 as=0.0567 ps=0.69 w=0.42 l=0.15
X18 VPWR a_652_21# a_562_413# VPB sky130_fd_pr__pfet_01v8_hvt ad=0.0798 pd=0.8 as=0.0945 ps=0.87 w=0.42 l=0.15
X19 VPWR SET_B a_1032_413# VPB sky130_fd_pr__pfet_01v8_hvt ad=0.123 pd=1.17 as=0.109 ps=1.36 w=0.42 l=0.15
X20 a_1032_413# a_27_47# a_956_413# VPB sky130_fd_pr__pfet_01v8_hvt ad=0.0819 pd=0.81 as=0.0483 ps=0.65 w=0.42 l=0.15
X21 a_1182_261# a_1032_413# VPWR VPB sky130_fd_pr__pfet_01v8_hvt ad=0.218 pd=2.2 as=0.123 ps=1.17 w=0.84 l=0.15
X22 Q a_1602_47# VGND VNB sky130_fd_pr__nfet_01v8 ad=0.169 pd=1.82 as=0.097 ps=0.975 w=0.65 l=0.15
X23 a_193_47# a_27_47# VPWR VPB sky130_fd_pr__pfet_01v8_hvt ad=0.166 pd=1.8 as=0.0864 ps=0.91 w=0.64 l=0.15
X24 a_1140_413# a_193_47# a_1032_413# VPB sky130_fd_pr__pfet_01v8_hvt ad=0.0441 pd=0.63 as=0.0819 ps=0.81 w=0.42 l=0.15
X25 VPWR a_1032_413# a_1602_47# VPB sky130_fd_pr__pfet_01v8_hvt ad=0.149 pd=1.33 as=0.166 ps=1.8 w=0.64 l=0.15
X26 a_796_47# SET_B VGND VNB sky130_fd_pr__nfet_01v8 ad=0.0441 pd=0.63 as=0.0882 ps=0.84 w=0.42 l=0.15
X27 a_381_47# D VGND VNB sky130_fd_pr__nfet_01v8 ad=0.0935 pd=0.965 as=0.166 ps=1.8 w=0.64 l=0.15
X28 a_1182_261# a_1032_413# VGND VNB sky130_fd_pr__nfet_01v8 ad=0.14 pd=1.6 as=0.114 ps=1.01 w=0.54 l=0.15
X29 a_652_21# a_476_47# a_796_47# VNB sky130_fd_pr__nfet_01v8 ad=0.109 pd=1.36 as=0.0441 ps=0.63 w=0.42 l=0.15
X30 VGND CLK a_27_47# VNB sky130_fd_pr__nfet_01v8 ad=0.0567 pd=0.69 as=0.109 ps=1.36 w=0.42 l=0.15
X31 VGND SET_B a_1296_47# VNB sky130_fd_pr__nfet_01v8 ad=0.114 pd=1.01 as=0.0483 ps=0.65 w=0.42 l=0.15
.ends

.subckt adc_readout VGND VPWR clk cs_n dbg_mode[0] dbg_mode[1] debug[0] debug[1] debug[2]
+ debug[3] debug[4] debug[5] debug[6] debug[7] err_clr osr_sel rst_n sclk sdo tap_n[0]
+ tap_n[10] tap_n[11] tap_n[12] tap_n[13] tap_n[14] tap_n[1] tap_n[2] tap_n[3] tap_n[4]
+ tap_n[5] tap_n[6] tap_n[7] tap_n[8] tap_n[9] tap_p[0] tap_p[10] tap_p[11] tap_p[12]
+ tap_p[13] tap_p[14] tap_p[1] tap_p[2] tap_p[3] tap_p[4] tap_p[5] tap_p[6] tap_p[7]
+ tap_p[8] tap_p[9] wrap_err
XFILLER_0_27_60 VPWR VGND VPWR VGND sky130_fd_sc_hd__decap_3
XANTENNA__506__RESET_B rst_n VGND VPWR VPWR VGND sky130_fd_sc_hd__diode_2
XFILLER_0_17_255 VPWR VGND VPWR VGND sky130_fd_sc_hd__decap_3
XFILLER_0_4_193 VPWR VGND VPWR VGND sky130_fd_sc_hd__decap_3
XFILLER_0_4_160 VPWR VGND VPWR VGND sky130_fd_sc_hd__decap_3
XFILLER_0_7_92 VPWR VGND VPWR VGND sky130_fd_sc_hd__decap_3
X_432_ sync[2] clknet_4_9_0_clk meta[2] VPWR VGND VPWR VGND sky130_fd_sc_hd__dfxtp_1
X_501_ VGND VPWR VPWR VGND clknet_1_1__leaf_vp.cg.gclk _114_[5] rst_n vp.divided sky130_fd_sc_hd__dfrtp_1
XFILLER_0_23_29 VPWR VGND VPWR VGND sky130_fd_sc_hd__decap_3
X_294_ VGND VPWR VPWR VGND clknet_4_7_0_clk _004_ run_n wrap_err sky130_fd_sc_hd__dfrtp_4
X_363_ VGND VPWR VPWR VGND clknet_4_11_0_clk add1.bit_add\[11\].fa.sum net2 add1.bit_add\[11\].fa.a
+ sky130_fd_sc_hd__dfrtp_1
Xadd1.bit_add\[13\].fa.fa VPWR VGND VGND VPWR net1 add1.bit_add\[13\].fa.co add1.bit_add\[13\].fa.a
+ add1.bit_add\[12\].fa.co add1.bit_add\[13\].fa.sum sky130_fd_sc_hd__fa_1
XFILLER_0_13_51 VPWR VGND VPWR VGND sky130_fd_sc_hd__decap_3
XPHY_EDGE_ROW_0_Left_34 VPWR VGND VPWR VGND sky130_fd_sc_hd__decap_3
XANTENNA__499__RESET_B rst_n VGND VPWR VPWR VGND sky130_fd_sc_hd__diode_2
X_346_ VGND VPWR VPWR VGND clknet_4_15_0_clk _002_[2] run_n phase[2] sky130_fd_sc_hd__dfrtp_4
X_415_ meta[15] clknet_4_0_0_clk clknet_1_0__leaf_tap_p[0] VPWR VGND VPWR VGND sky130_fd_sc_hd__dfxtp_1
X_277_ VGND VPWR VPWR VGND sync[23] pp.column\[2\].fa.ci prev[23] sky130_fd_sc_hd__xor2_1
XFILLER_0_11_217 VPWR VGND VPWR VGND sky130_fd_sc_hd__decap_3
XFILLER_0_11_228 VPWR VGND VPWR VGND sky130_fd_sc_hd__decap_3
Xclkbuf_1_0__f_g_work.gclk VGND VPWR clknet_0_g_work.gclk clknet_1_0__leaf_g_work.gclk
+ VPWR VGND sky130_fd_sc_hd__clkbuf_4
Xclkbuf_4_12_0_clk VGND VPWR clknet_0_clk clknet_4_12_0_clk VPWR VGND sky130_fd_sc_hd__clkbuf_4
XFILLER_0_10_272 VPWR VGND VPWR VGND sky130_fd_sc_hd__decap_3
XFILLER_0_10_283 VPWR VGND VPWR VGND sky130_fd_sc_hd__decap_3
X_200_ VPWR VGND VGND VPWR dbg_mode[1] dbg_mode[0] vn.cg.en sky130_fd_sc_hd__lpflow_isobufsrc_1
X_131_ VPWR VGND VGND VPWR work[20] _024_ work[19] phase[2] sky130_fd_sc_hd__mux2i_1
XFILLER_0_0_18 VPWR VGND VPWR VGND sky130_fd_sc_hd__decap_3
XFILLER_0_0_29 VPWR VGND VPWR VGND sky130_fd_sc_hd__decap_3
XFILLER_0_28_114 VPWR VGND VPWR VGND sky130_fd_sc_hd__decap_3
XFILLER_0_9_27 VPWR VGND VPWR VGND sky130_fd_sc_hd__decap_3
XFILLER_0_16_309 VPWR VGND VPWR VGND sky130_fd_sc_hd__decap_3
X_329_ delay2[9] clknet_2_0__leaf_g_delay.gclk delay2[10] VPWR VGND VPWR VGND sky130_fd_sc_hd__dfxtp_1
XFILLER_0_3_269 VPWR VGND VPWR VGND sky130_fd_sc_hd__decap_3
XFILLER_0_10_41 VPWR VGND VPWR VGND sky130_fd_sc_hd__decap_3
XFILLER_0_10_74 VPWR VGND VPWR VGND sky130_fd_sc_hd__decap_3
XFILLER_0_10_85 VPWR VGND VPWR VGND sky130_fd_sc_hd__decap_3
XFILLER_0_30_312 VPWR VGND VPWR VGND sky130_fd_sc_hd__decap_3
XFILLER_0_19_169 VPWR VGND VPWR VGND sky130_fd_sc_hd__decap_3
XFILLER_0_0_217 VPWR VGND VPWR VGND sky130_fd_sc_hd__decap_3
XFILLER_0_12_301 VPWR VGND VPWR VGND sky130_fd_sc_hd__decap_3
XFILLER_0_12_312 VPWR VGND VPWR VGND sky130_fd_sc_hd__decap_3
XFILLER_0_30_197 VPWR VGND VPWR VGND sky130_fd_sc_hd__decap_3
Xbit_store\[19\].ff VPWR VGND work[19] clknet_1_0__leaf_g_work.gclk work[20] capture
+ net8 VPWR VGND sky130_fd_sc_hd__sdfxtp_1
XFILLER_0_16_62 VPWR VGND VPWR VGND sky130_fd_sc_hd__decap_3
XFILLER_0_20_9 VPWR VGND VPWR VGND sky130_fd_sc_hd__decap_3
XFILLER_0_8_125 VPWR VGND VPWR VGND sky130_fd_sc_hd__decap_3
XFILLER_0_12_153 VPWR VGND VPWR VGND sky130_fd_sc_hd__decap_3
XFILLER_0_12_186 VPWR VGND VPWR VGND sky130_fd_sc_hd__decap_3
XFILLER_0_12_197 VPWR VGND VPWR VGND sky130_fd_sc_hd__decap_3
X_500_ VGND VPWR VPWR VGND clknet_1_1__leaf_vp.cg.gclk _114_[4] rst_n vp.count[4]
+ sky130_fd_sc_hd__dfrtp_1
X_431_ sync[1] clknet_4_9_0_clk meta[1] VPWR VGND VPWR VGND sky130_fd_sc_hd__dfxtp_1
X_362_ VGND VPWR VPWR VGND clknet_4_11_0_clk add1.bit_add\[10\].fa.sum net2 add1.bit_add\[10\].fa.a
+ sky130_fd_sc_hd__dfrtp_1
Xbit_store\[6\].ff VPWR VGND work[6] clknet_1_1__leaf_g_work.gclk work[7] capture
+ net28 VPWR VGND sky130_fd_sc_hd__sdfxtp_1
X_293_ VGND VPWR VPWR VGND vn.divided _112_[5] _110_ sky130_fd_sc_hd__xor2_1
XFILLER_0_3_18 VPWR VGND VPWR VGND sky130_fd_sc_hd__decap_3
XFILLER_0_13_30 VPWR VGND VPWR VGND sky130_fd_sc_hd__decap_3
XFILLER_0_13_96 VPWR VGND VPWR VGND sky130_fd_sc_hd__decap_3
Xadd2.bit_add\[9\].fa.fa VPWR VGND VGND VPWR add1.bit_add\[9\].fa.a add2.bit_add\[10\].fa.ci
+ add2.bit_add\[9\].fa.a add2.bit_add\[8\].fa.co add2.bit_add\[9\].fa.sum sky130_fd_sc_hd__fa_1
XFILLER_0_13_270 VPWR VGND VPWR VGND sky130_fd_sc_hd__decap_3
XFILLER_0_13_281 VPWR VGND VPWR VGND sky130_fd_sc_hd__decap_3
X_345_ VGND VPWR VPWR VGND clknet_4_15_0_clk _002_[1] run_n phase[1] sky130_fd_sc_hd__dfrtp_4
X_276_ VGND VPWR VPWR VGND sync[22] pp.column\[2\].fa.b prev[22] sky130_fd_sc_hd__xor2_1
X_414_ meta[14] clknet_4_11_0_clk tap_n[14] VPWR VGND VPWR VGND sky130_fd_sc_hd__dfxtp_1
XFILLER_0_24_73 VPWR VGND VPWR VGND sky130_fd_sc_hd__decap_3
XPHY_EDGE_ROW_12_Right_12 VPWR VGND VPWR VGND sky130_fd_sc_hd__decap_3
XPHY_EDGE_ROW_21_Right_21 VPWR VGND VPWR VGND sky130_fd_sc_hd__decap_3
X_130_ VPWR VGND VGND VPWR work[18] _023_ work[17] phase[2] sky130_fd_sc_hd__mux2i_1
XPHY_EDGE_ROW_30_Right_30 VPWR VGND VPWR VGND sky130_fd_sc_hd__decap_3
X_259_ VGND VPWR VPWR VGND sync[5] pn.column\[1\].fa.ci prev[5] sky130_fd_sc_hd__xor2_1
XFILLER_0_9_39 VPWR VGND VPWR VGND sky130_fd_sc_hd__decap_3
X_328_ delay2[8] clknet_2_2__leaf_g_delay.gclk delay2[9] VPWR VGND VPWR VGND sky130_fd_sc_hd__dfxtp_1
XFILLER_0_10_53 VPWR VGND VPWR VGND sky130_fd_sc_hd__decap_3
XFILLER_0_10_97 VPWR VGND VPWR VGND sky130_fd_sc_hd__decap_3
XFILLER_0_29_6 VPWR VGND VPWR VGND sky130_fd_sc_hd__decap_3
XFILLER_0_30_302 VPWR VGND VPWR VGND sky130_fd_sc_hd__decap_3
XFILLER_0_15_310 VPWR VGND VPWR VGND sky130_fd_sc_hd__decap_3
Xpn.f1.fa VPWR VGND VGND VPWR pn.column\[3\].fa.sum pn.f1.co pn.column\[4\].fa.sum
+ pn.f0.sum pn.f1.sum sky130_fd_sc_hd__fa_2
XFILLER_0_18_170 VPWR VGND VPWR VGND sky130_fd_sc_hd__decap_3
XFILLER_0_21_313 VPWR VGND VPWR VGND sky130_fd_sc_hd__decap_3
Xclkbuf_4_11_0_clk VGND VPWR clknet_0_clk clknet_4_11_0_clk VPWR VGND sky130_fd_sc_hd__clkbuf_4
XFILLER_0_21_63 VPWR VGND VPWR VGND sky130_fd_sc_hd__decap_3
XFILLER_0_27_3 VPWR VGND VPWR VGND sky130_fd_sc_hd__decap_3
Xhold20 net27 add2.bit_add\[5\].fa.a VPWR VGND VGND VPWR sky130_fd_sc_hd__dlygate4sd3_1
XFILLER_0_6_18 VPWR VGND VPWR VGND sky130_fd_sc_hd__decap_3
XFILLER_0_21_165 VPWR VGND VPWR VGND sky130_fd_sc_hd__decap_3
XFILLER_0_13_9 VPWR VGND VPWR VGND sky130_fd_sc_hd__decap_3
XFILLER_0_29_298 VPWR VGND VPWR VGND sky130_fd_sc_hd__decap_3
XFILLER_0_8_104 VPWR VGND VPWR VGND sky130_fd_sc_hd__decap_3
XPHY_EDGE_ROW_6_Right_6 VPWR VGND VPWR VGND sky130_fd_sc_hd__decap_3
XFILLER_0_12_121 VPWR VGND VPWR VGND sky130_fd_sc_hd__decap_3
XFILLER_0_12_165 VPWR VGND VPWR VGND sky130_fd_sc_hd__decap_3
XFILLER_0_1_313 VPWR VGND VPWR VGND sky130_fd_sc_hd__decap_3
XFILLER_0_27_51 VPWR VGND VPWR VGND sky130_fd_sc_hd__decap_3
XFILLER_0_11_6 VPWR VGND VPWR VGND sky130_fd_sc_hd__decap_3
XFILLER_0_2_9 VPWR VGND VPWR VGND sky130_fd_sc_hd__decap_3
Xadd2.bit_add\[5\].fa.fa VPWR VGND VGND VPWR add1.bit_add\[5\].fa.a add2.bit_add\[5\].fa.co
+ add2.bit_add\[5\].fa.a add2.bit_add\[4\].fa.co add2.bit_add\[5\].fa.sum sky130_fd_sc_hd__fa_1
X_430_ sync[0] clknet_4_9_0_clk meta[0] VPWR VGND VPWR VGND sky130_fd_sc_hd__dfxtp_1
X_361_ VGND VPWR VPWR VGND clknet_4_14_0_clk add1.bit_add\[9\].fa.sum net2 add1.bit_add\[9\].fa.a
+ sky130_fd_sc_hd__dfrtp_1
X_292_ VGND VPWR _108_ _112_[4] vn.count[4] VPWR VGND sky130_fd_sc_hd__xnor2_1
XFILLER_0_23_216 VPWR VGND VPWR VGND sky130_fd_sc_hd__decap_3
XFILLER_0_13_42 VPWR VGND VPWR VGND sky130_fd_sc_hd__decap_3
XFILLER_0_13_64 VPWR VGND VPWR VGND sky130_fd_sc_hd__decap_3
XFILLER_0_14_249 VPWR VGND VPWR VGND sky130_fd_sc_hd__decap_3
XFILLER_0_9_221 VPWR VGND VPWR VGND sky130_fd_sc_hd__decap_3
XFILLER_0_0_6 VPWR VGND VPWR VGND sky130_fd_sc_hd__decap_3
XFILLER_0_13_293 VPWR VGND VPWR VGND sky130_fd_sc_hd__decap_3
X_413_ meta[13] clknet_4_11_0_clk tap_n[13] VPWR VGND VPWR VGND sky130_fd_sc_hd__dfxtp_1
Xpn.f4.fa VPWR VGND VGND VPWR pn.f2.sum pn.f4.co pn.f3.sum pn.f1.co pn.f4.sum sky130_fd_sc_hd__fa_2
X_344_ VGND VPWR VPWR VGND clknet_4_15_0_clk _002_[0] run_n phase[0] sky130_fd_sc_hd__dfrtp_4
X_275_ VGND VPWR VPWR VGND sync[21] pp.column\[2\].fa.a prev[21] sky130_fd_sc_hd__xor2_1
XFILLER_0_11_208 VPWR VGND VPWR VGND sky130_fd_sc_hd__decap_3
XFILLER_0_24_41 VPWR VGND VPWR VGND sky130_fd_sc_hd__decap_3
XFILLER_0_6_235 VPWR VGND VPWR VGND sky130_fd_sc_hd__decap_3
XFILLER_0_10_263 VPWR VGND VPWR VGND sky130_fd_sc_hd__decap_3
XFILLER_0_4_73 VPWR VGND VPWR VGND sky130_fd_sc_hd__decap_3
XFILLER_0_5_290 VPWR VGND VPWR VGND sky130_fd_sc_hd__decap_3
X_189_ VGND VPWR _074_ rate rate_sync[1] VPWR VGND sky130_fd_sc_hd__xnor2_2
XFILLER_0_3_216 VPWR VGND VPWR VGND sky130_fd_sc_hd__decap_3
X_258_ VGND VPWR VPWR VGND sync[4] pn.column\[1\].fa.b prev[4] sky130_fd_sc_hd__xor2_1
XFILLER_0_9_18 VPWR VGND VPWR VGND sky130_fd_sc_hd__decap_3
XFILLER_0_10_21 VPWR VGND VPWR VGND sky130_fd_sc_hd__decap_3
XFILLER_0_10_32 VPWR VGND VPWR VGND sky130_fd_sc_hd__decap_3
X_327_ delay2[7] clknet_2_0__leaf_g_delay.gclk delay2[8] VPWR VGND VPWR VGND sky130_fd_sc_hd__dfxtp_1
XFILLER_0_10_65 VPWR VGND VPWR VGND sky130_fd_sc_hd__decap_3
XFILLER_0_19_63 VPWR VGND VPWR VGND sky130_fd_sc_hd__decap_3
XFILLER_0_18_182 VPWR VGND VPWR VGND sky130_fd_sc_hd__decap_3
XFILLER_0_24_174 VPWR VGND VPWR VGND sky130_fd_sc_hd__decap_3
XFILLER_0_21_86 VPWR VGND VPWR VGND sky130_fd_sc_hd__decap_3
XFILLER_0_15_196 VPWR VGND VPWR VGND sky130_fd_sc_hd__decap_3
Xhold21 net28 add2.bit_add\[6\].fa.a VPWR VGND VGND VPWR sky130_fd_sc_hd__dlygate4sd3_1
Xhold10 net17 add2.bit_add\[2\].fa.a VPWR VGND VGND VPWR sky130_fd_sc_hd__dlygate4sd3_1
XFILLER_0_16_53 VPWR VGND VPWR VGND sky130_fd_sc_hd__decap_3
XFILLER_0_8_116 VPWR VGND VPWR VGND sky130_fd_sc_hd__decap_3
XFILLER_0_12_100 VPWR VGND VPWR VGND sky130_fd_sc_hd__decap_3
XFILLER_0_12_133 VPWR VGND VPWR VGND sky130_fd_sc_hd__decap_3
XFILLER_0_12_144 VPWR VGND VPWR VGND sky130_fd_sc_hd__decap_3
XFILLER_0_12_177 VPWR VGND VPWR VGND sky130_fd_sc_hd__decap_3
Xadd2.bit_add\[1\].fa.fa VPWR VGND VGND VPWR add1.bit_add\[1\].fa.a add2.bit_add\[1\].fa.co
+ add2.bit_add\[1\].fa.a add2.bit_add\[0\].fa.co add2.bit_add\[1\].fa.sum sky130_fd_sc_hd__fa_1
Xclkbuf_4_10_0_clk VGND VPWR clknet_0_clk clknet_4_10_0_clk VPWR VGND sky130_fd_sc_hd__clkbuf_4
XFILLER_0_9_3 VPWR VGND VPWR VGND sky130_fd_sc_hd__decap_3
XFILLER_0_5_119 VPWR VGND VPWR VGND sky130_fd_sc_hd__decap_3
XFILLER_0_27_63 VPWR VGND VPWR VGND sky130_fd_sc_hd__decap_3
XFILLER_0_17_258 VPWR VGND VPWR VGND sky130_fd_sc_hd__decap_3
X_360_ VGND VPWR VPWR VGND clknet_4_14_0_clk add1.bit_add\[8\].fa.sum net2 add1.bit_add\[8\].fa.a
+ sky130_fd_sc_hd__dfrtp_1
X_291_ VPWR VGND VGND VPWR vn.count[4] _108_ _110_ sky130_fd_sc_hd__lpflow_isobufsrc_1
XFILLER_0_16_280 VPWR VGND VPWR VGND sky130_fd_sc_hd__decap_3
XFILLER_0_13_21 VPWR VGND VPWR VGND sky130_fd_sc_hd__decap_3
X_489_ prev[29] clknet_4_8_0_clk sync[29] VPWR VGND VPWR VGND sky130_fd_sc_hd__dfxtp_1
XPHY_EDGE_ROW_19_Left_53 VPWR VGND VPWR VGND sky130_fd_sc_hd__decap_3
XFILLER_0_28_309 VPWR VGND VPWR VGND sky130_fd_sc_hd__decap_3
X_412_ meta[12] clknet_4_11_0_clk tap_n[12] VPWR VGND VPWR VGND sky130_fd_sc_hd__dfxtp_1
X_343_ VGND VPWR VPWR VGND clknet_4_13_0_clk _009_ run_n rate sky130_fd_sc_hd__dfrtp_4
X_274_ VGND VPWR VPWR VGND sync[20] pp.column\[1\].fa.ci prev[20] sky130_fd_sc_hd__xor2_1
XFILLER_0_24_64 VPWR VGND VPWR VGND sky130_fd_sc_hd__decap_3
Xclkbuf_1_1__f_vn.cg.gclk VGND VPWR clknet_0_vn.cg.gclk clknet_1_1__leaf_vn.cg.gclk
+ VPWR VGND sky130_fd_sc_hd__clkbuf_4
XFILLER_0_10_286 VPWR VGND VPWR VGND sky130_fd_sc_hd__decap_3
XPHY_EDGE_ROW_4_Left_38 VPWR VGND VPWR VGND sky130_fd_sc_hd__decap_3
XFILLER_0_33_312 VPWR VGND VPWR VGND sky130_fd_sc_hd__decap_3
XFILLER_0_28_117 VPWR VGND VPWR VGND sky130_fd_sc_hd__decap_3
X_326_ delay2[6] clknet_2_2__leaf_g_delay.gclk delay2[7] VPWR VGND VPWR VGND sky130_fd_sc_hd__dfxtp_1
X_188_ VGND VPWR VGND VPWR _055_ _019_ _073_ _014_ phase[6] sky130_fd_sc_hd__nand4_2
XFILLER_0_24_312 VPWR VGND VPWR VGND sky130_fd_sc_hd__decap_3
X_257_ VGND VPWR VPWR VGND sync[3] pn.column\[1\].fa.a prev[3] sky130_fd_sc_hd__xor2_1
XFILLER_0_10_44 VPWR VGND VPWR VGND sky130_fd_sc_hd__decap_3
XFILLER_0_10_77 VPWR VGND VPWR VGND sky130_fd_sc_hd__decap_3
XFILLER_0_10_88 VPWR VGND VPWR VGND sky130_fd_sc_hd__decap_3
XFILLER_0_19_53 VPWR VGND VPWR VGND sky130_fd_sc_hd__decap_3
XFILLER_0_27_194 VPWR VGND VPWR VGND sky130_fd_sc_hd__decap_3
XFILLER_0_15_301 VPWR VGND VPWR VGND sky130_fd_sc_hd__decap_3
XFILLER_0_33_197 VPWR VGND VPWR VGND sky130_fd_sc_hd__decap_3
XFILLER_0_18_161 VPWR VGND VPWR VGND sky130_fd_sc_hd__decap_3
XANTENNA__402__D tap_n[2] VGND VPWR VPWR VGND sky130_fd_sc_hd__diode_2
X_309_ delay1[10] clknet_2_1__leaf_g_delay.gclk delay1[11] VPWR VGND VPWR VGND sky130_fd_sc_hd__dfxtp_1
XFILLER_0_8_309 VPWR VGND VPWR VGND sky130_fd_sc_hd__decap_3
XFILLER_0_12_304 VPWR VGND VPWR VGND sky130_fd_sc_hd__decap_3
Xhold22 net29 borrow2 VPWR VGND VGND VPWR sky130_fd_sc_hd__dlygate4sd3_1
Xhold11 net18 add2.bit_add\[20\].fa.a VPWR VGND VGND VPWR sky130_fd_sc_hd__dlygate4sd3_1
Xbit_store\[9\].ff VPWR VGND work[9] clknet_1_1__leaf_g_work.gclk work[10] capture
+ net24 VPWR VGND sky130_fd_sc_hd__sdfxtp_1
XPHY_EDGE_ROW_7_Left_41 VPWR VGND VPWR VGND sky130_fd_sc_hd__decap_3
XFILLER_0_29_289 VPWR VGND VPWR VGND sky130_fd_sc_hd__decap_3
XFILLER_0_4_312 VPWR VGND VPWR VGND sky130_fd_sc_hd__decap_3
XFILLER_0_4_301 VPWR VGND VPWR VGND sky130_fd_sc_hd__decap_3
XFILLER_0_8_128 VPWR VGND VPWR VGND sky130_fd_sc_hd__decap_3
XFILLER_0_12_112 VPWR VGND VPWR VGND sky130_fd_sc_hd__decap_3
XFILLER_0_12_156 VPWR VGND VPWR VGND sky130_fd_sc_hd__decap_3
XFILLER_0_12_189 VPWR VGND VPWR VGND sky130_fd_sc_hd__decap_3
XFILLER_0_32_3 VPWR VGND VPWR VGND sky130_fd_sc_hd__decap_3
XPHY_EDGE_ROW_33_Left_67 VPWR VGND VPWR VGND sky130_fd_sc_hd__decap_3
XFILLER_0_7_172 VPWR VGND VPWR VGND sky130_fd_sc_hd__decap_3
XFILLER_0_4_197 VPWR VGND VPWR VGND sky130_fd_sc_hd__decap_3
X_290_ VPWR VGND VGND VPWR _108_ _109_ _112_[3] sky130_fd_sc_hd__lpflow_isobufsrc_1
XANTENNA__410__D tap_n[10] VGND VPWR VPWR VGND sky130_fd_sc_hd__diode_2
X_488_ prev[28] clknet_4_2_0_clk sync[28] VPWR VGND VPWR VGND sky130_fd_sc_hd__dfxtp_1
XFILLER_0_13_33 VPWR VGND VPWR VGND sky130_fd_sc_hd__decap_3
XFILLER_0_13_99 VPWR VGND VPWR VGND sky130_fd_sc_hd__decap_3
XFILLER_0_13_273 VPWR VGND VPWR VGND sky130_fd_sc_hd__decap_3
XFILLER_0_13_284 VPWR VGND VPWR VGND sky130_fd_sc_hd__decap_3
X_342_ VGND VPWR VPWR VGND clknet_4_13_0_clk _008_ run_n history_valid sky130_fd_sc_hd__dfrtp_1
X_411_ meta[11] clknet_4_11_0_clk tap_n[11] VPWR VGND VPWR VGND sky130_fd_sc_hd__dfxtp_1
X_273_ VGND VPWR VPWR VGND sync[19] pp.column\[1\].fa.b prev[19] sky130_fd_sc_hd__xor2_1
XANTENNA__405__D tap_n[5] VGND VPWR VPWR VGND sky130_fd_sc_hd__diode_2
XFILLER_0_24_32 VPWR VGND VPWR VGND sky130_fd_sc_hd__decap_3
XPHY_EDGE_ROW_20_Left_54 VPWR VGND VPWR VGND sky130_fd_sc_hd__decap_3
XFILLER_0_24_76 VPWR VGND VPWR VGND sky130_fd_sc_hd__decap_3
XFILLER_0_33_302 VPWR VGND VPWR VGND sky130_fd_sc_hd__decap_3
XFILLER_0_5_281 VPWR VGND VPWR VGND sky130_fd_sc_hd__decap_3
X_325_ delay2[5] clknet_2_2__leaf_g_delay.gclk delay2[6] VPWR VGND VPWR VGND sky130_fd_sc_hd__dfxtp_1
X_187_ VPWR VGND VPWR VGND _072_ borrow2 _064_ _007_ g_delay.en sky130_fd_sc_hd__a22o_1
X_256_ VGND VPWR VPWR VGND sync[2] pn.column\[0\].fa.ci prev[2] sky130_fd_sc_hd__xor2_1
XFILLER_0_10_12 VPWR VGND VPWR VGND sky130_fd_sc_hd__decap_3
XFILLER_0_10_56 VPWR VGND VPWR VGND sky130_fd_sc_hd__decap_3
XFILLER_0_29_9 VPWR VGND VPWR VGND sky130_fd_sc_hd__decap_3
XFILLER_0_15_313 VPWR VGND VPWR VGND sky130_fd_sc_hd__decap_3
XFILLER_0_30_305 VPWR VGND VPWR VGND sky130_fd_sc_hd__decap_3
XFILLER_0_18_173 VPWR VGND VPWR VGND sky130_fd_sc_hd__decap_3
Xclkbuf_2_1__f_g_delay.gclk VGND VPWR clknet_0_g_delay.gclk clknet_2_1__leaf_g_delay.gclk
+ VPWR VGND sky130_fd_sc_hd__clkbuf_4
X_239_ VPWR VGND VGND VPWR _075_ _100_ _002_[5] sky130_fd_sc_hd__nor2_1
X_308_ delay1[9] clknet_2_1__leaf_g_delay.gclk delay1[10] VPWR VGND VPWR VGND sky130_fd_sc_hd__dfxtp_1
XFILLER_0_21_66 VPWR VGND VPWR VGND sky130_fd_sc_hd__decap_3
XFILLER_0_27_6 VPWR VGND VPWR VGND sky130_fd_sc_hd__decap_3
Xhold23 VGND VPWR VPWR VGND borrow1 net30 sky130_fd_sc_hd__clkdlybuf4s25_1
Xhold12 net19 add2.bit_add\[16\].fa.a VPWR VGND VGND VPWR sky130_fd_sc_hd__dlygate4sd3_1
XANTENNA__413__D tap_n[13] VGND VPWR VPWR VGND sky130_fd_sc_hd__diode_2
XFILLER_0_32_21 VPWR VGND VPWR VGND sky130_fd_sc_hd__decap_3
XFILLER_0_8_107 VPWR VGND VPWR VGND sky130_fd_sc_hd__decap_3
XFILLER_0_12_124 VPWR VGND VPWR VGND sky130_fd_sc_hd__decap_3
XANTENNA_clkbuf_0_clk_A clk VGND VPWR VPWR VGND sky130_fd_sc_hd__diode_2
XFILLER_0_12_168 VPWR VGND VPWR VGND sky130_fd_sc_hd__decap_3
XFILLER_0_25_3 VPWR VGND VPWR VGND sky130_fd_sc_hd__decap_3
XFILLER_0_11_190 VPWR VGND VPWR VGND sky130_fd_sc_hd__decap_3
XANTENNA__408__D tap_n[8] VGND VPWR VPWR VGND sky130_fd_sc_hd__diode_2
XPHY_EDGE_ROW_19_Right_19 VPWR VGND VPWR VGND sky130_fd_sc_hd__decap_3
XPHY_EDGE_ROW_28_Right_28 VPWR VGND VPWR VGND sky130_fd_sc_hd__decap_3
XFILLER_0_11_9 VPWR VGND VPWR VGND sky130_fd_sc_hd__decap_3
XFILLER_0_17_249 VPWR VGND VPWR VGND sky130_fd_sc_hd__decap_3
XFILLER_0_4_187 VPWR VGND VPWR VGND sky130_fd_sc_hd__decap_3
XFILLER_0_7_64 VPWR VGND VPWR VGND sky130_fd_sc_hd__decap_3
XFILLER_0_31_274 VPWR VGND VPWR VGND sky130_fd_sc_hd__decap_3
X_487_ prev[27] clknet_4_8_0_clk sync[27] VPWR VGND VPWR VGND sky130_fd_sc_hd__dfxtp_1
XFILLER_0_13_12 VPWR VGND VPWR VGND sky130_fd_sc_hd__decap_3
XFILLER_0_13_45 VPWR VGND VPWR VGND sky130_fd_sc_hd__decap_3
XFILLER_0_22_274 VPWR VGND VPWR VGND sky130_fd_sc_hd__decap_3
XFILLER_0_0_9 VPWR VGND VPWR VGND sky130_fd_sc_hd__decap_3
XFILLER_0_0_190 VPWR VGND VPWR VGND sky130_fd_sc_hd__decap_3
XFILLER_0_13_296 VPWR VGND VPWR VGND sky130_fd_sc_hd__decap_3
X_341_ VGND VPWR VPWR VGND clknet_4_5_0_clk _007_ run_n borrow2 sky130_fd_sc_hd__dfrtp_1
X_410_ meta[10] clknet_4_11_0_clk tap_n[10] VPWR VGND VPWR VGND sky130_fd_sc_hd__dfxtp_1
X_272_ VGND VPWR VPWR VGND sync[18] pp.column\[1\].fa.a prev[18] sky130_fd_sc_hd__xor2_1
XANTENNA__421__D tap_p[6] VGND VPWR VPWR VGND sky130_fd_sc_hd__diode_2
XFILLER_0_24_44 VPWR VGND VPWR VGND sky130_fd_sc_hd__decap_3
XFILLER_0_27_300 VPWR VGND VPWR VGND sky130_fd_sc_hd__decap_3
XFILLER_0_6_238 VPWR VGND VPWR VGND sky130_fd_sc_hd__decap_3
XFILLER_0_10_266 VPWR VGND VPWR VGND sky130_fd_sc_hd__decap_3
XFILLER_0_4_76 VPWR VGND VPWR VGND sky130_fd_sc_hd__decap_3
XFILLER_0_4_21 VPWR VGND VPWR VGND sky130_fd_sc_hd__decap_3
XFILLER_0_10_299 VPWR VGND VPWR VGND sky130_fd_sc_hd__decap_3
XFILLER_0_5_293 VPWR VGND VPWR VGND sky130_fd_sc_hd__decap_3
XANTENNA_clkbuf_0_tap_n[0]_A tap_n[0] VGND VPWR VPWR VGND sky130_fd_sc_hd__diode_2
XANTENNA__416__D tap_p[1] VGND VPWR VPWR VGND sky130_fd_sc_hd__diode_2
X_255_ VGND VPWR VPWR VGND sync[1] pn.column\[0\].fa.b prev[1] sky130_fd_sc_hd__xor2_1
X_324_ delay2[4] clknet_2_2__leaf_g_delay.gclk delay2[5] VPWR VGND VPWR VGND sky130_fd_sc_hd__dfxtp_1
X_186_ VPWR VGND VGND VPWR _072_ _070_ borrow2 _069_ sky130_fd_sc_hd__maj3_1
XFILLER_0_3_219 VPWR VGND VPWR VGND sky130_fd_sc_hd__decap_3
XFILLER_0_10_24 VPWR VGND VPWR VGND sky130_fd_sc_hd__decap_3
XFILLER_0_10_35 VPWR VGND VPWR VGND sky130_fd_sc_hd__decap_3
XFILLER_0_10_68 VPWR VGND VPWR VGND sky130_fd_sc_hd__decap_3
XFILLER_0_19_66 VPWR VGND VPWR VGND sky130_fd_sc_hd__decap_3
XFILLER_0_19_119 VPWR VGND VPWR VGND sky130_fd_sc_hd__decap_3
XFILLER_0_27_163 VPWR VGND VPWR VGND sky130_fd_sc_hd__decap_3
X_307_ delay1[8] clknet_2_1__leaf_g_delay.gclk delay1[9] VPWR VGND VPWR VGND sky130_fd_sc_hd__dfxtp_1
X_238_ VGND VPWR VPWR VGND phase[5] _100_ _098_ sky130_fd_sc_hd__xor2_1
X_169_ VPWR VGND VPWR VGND phase[7] phase[5] phase[6] _059_ phase[4] sky130_fd_sc_hd__or4b_1
XFILLER_0_24_133 VPWR VGND VPWR VGND sky130_fd_sc_hd__decap_3
XFILLER_0_21_89 VPWR VGND VPWR VGND sky130_fd_sc_hd__decap_3
XFILLER_0_15_155 VPWR VGND VPWR VGND sky130_fd_sc_hd__decap_3
XFILLER_0_15_199 VPWR VGND VPWR VGND sky130_fd_sc_hd__decap_3
Xadd2.bit_add\[17\].fa.fa VPWR VGND VGND VPWR add1.bit_add\[17\].fa.a add2.bit_add\[17\].fa.co
+ add2.bit_add\[17\].fa.a add2.bit_add\[16\].fa.co add2.bit_add\[17\].fa.sum sky130_fd_sc_hd__fa_1
Xhold13 net20 add2.bit_add\[11\].fa.a VPWR VGND VGND VPWR sky130_fd_sc_hd__dlygate4sd3_1
XFILLER_0_16_56 VPWR VGND VPWR VGND sky130_fd_sc_hd__decap_3
XFILLER_0_8_119 VPWR VGND VPWR VGND sky130_fd_sc_hd__decap_3
XFILLER_0_12_103 VPWR VGND VPWR VGND sky130_fd_sc_hd__decap_3
XFILLER_0_12_136 VPWR VGND VPWR VGND sky130_fd_sc_hd__decap_3
XFILLER_0_12_147 VPWR VGND VPWR VGND sky130_fd_sc_hd__decap_3
XFILLER_0_18_3 VPWR VGND VPWR VGND sky130_fd_sc_hd__decap_3
XFILLER_0_9_6 VPWR VGND VPWR VGND sky130_fd_sc_hd__decap_3
XANTENNA__424__D tap_p[9] VGND VPWR VPWR VGND sky130_fd_sc_hd__diode_2
XFILLER_0_4_133 VPWR VGND VPWR VGND sky130_fd_sc_hd__decap_3
XFILLER_0_7_3 VPWR VGND VPWR VGND sky130_fd_sc_hd__decap_3
XANTENNA__419__D tap_p[4] VGND VPWR VPWR VGND sky130_fd_sc_hd__diode_2
X_486_ prev[26] clknet_4_2_0_clk sync[26] VPWR VGND VPWR VGND sky130_fd_sc_hd__dfxtp_1
XFILLER_0_13_24 VPWR VGND VPWR VGND sky130_fd_sc_hd__decap_3
XFILLER_0_13_57 VPWR VGND VPWR VGND sky130_fd_sc_hd__decap_3
X_340_ delay2[20] clknet_2_0__leaf_g_delay.gclk first VPWR VGND VPWR VGND sky130_fd_sc_hd__dfxtp_1
X_271_ VGND VPWR VPWR VGND sync[17] pp.column\[0\].fa.ci prev[17] sky130_fd_sc_hd__xor2_1
XFILLER_0_24_67 VPWR VGND VPWR VGND sky130_fd_sc_hd__decap_3
XFILLER_0_24_23 VPWR VGND VPWR VGND sky130_fd_sc_hd__decap_3
XFILLER_0_27_312 VPWR VGND VPWR VGND sky130_fd_sc_hd__decap_3
X_469_ prev[9] clknet_4_11_0_clk sync[9] VPWR VGND VPWR VGND sky130_fd_sc_hd__dfxtp_1
Xadd1.bit_add\[9\].fa.fa VPWR VGND VGND VPWR net1 add1.bit_add\[10\].fa.ci add1.bit_add\[9\].fa.a
+ add1.bit_add\[8\].fa.co add1.bit_add\[9\].fa.sum sky130_fd_sc_hd__fa_1
XFILLER_0_10_289 VPWR VGND VPWR VGND sky130_fd_sc_hd__decap_3
XFILLER_0_18_312 VPWR VGND VPWR VGND sky130_fd_sc_hd__decap_3
X_185_ VGND VPWR VPWR VGND _069_ _071_ _070_ sky130_fd_sc_hd__xor2_1
X_254_ VGND VPWR VPWR VGND sync[0] pn.column\[0\].fa.a prev[0] sky130_fd_sc_hd__xor2_1
X_323_ delay2[3] clknet_2_2__leaf_g_delay.gclk delay2[4] VPWR VGND VPWR VGND sky130_fd_sc_hd__dfxtp_1
XFILLER_0_10_47 VPWR VGND VPWR VGND sky130_fd_sc_hd__decap_3
XFILLER_0_19_12 VPWR VGND VPWR VGND sky130_fd_sc_hd__decap_3
XFILLER_0_15_304 VPWR VGND VPWR VGND sky130_fd_sc_hd__decap_3
Xbit_store\[12\].ff VPWR VGND work[12] clknet_1_1__leaf_g_work.gclk work[13] capture
+ net23 VPWR VGND sky130_fd_sc_hd__sdfxtp_1
XFILLER_0_33_145 VPWR VGND VPWR VGND sky130_fd_sc_hd__decap_3
Xadd2.bit_add\[13\].fa.fa VPWR VGND VGND VPWR add1.bit_add\[13\].fa.a add2.bit_add\[13\].fa.co
+ add2.bit_add\[13\].fa.a add2.bit_add\[12\].fa.co add2.bit_add\[13\].fa.sum sky130_fd_sc_hd__fa_1
XFILLER_0_18_164 VPWR VGND VPWR VGND sky130_fd_sc_hd__decap_3
XFILLER_0_33_189 VPWR VGND VPWR VGND sky130_fd_sc_hd__decap_3
X_306_ delay1[7] clknet_2_1__leaf_g_delay.gclk delay1[8] VPWR VGND VPWR VGND sky130_fd_sc_hd__dfxtp_1
XANTENNA__427__D tap_p[12] VGND VPWR VPWR VGND sky130_fd_sc_hd__diode_2
X_237_ VPWR VGND VGND VPWR _075_ _099_ _002_[4] sky130_fd_sc_hd__nor2_1
X_168_ VPWR VGND VGND VPWR phase[3] phase[2] phase[1] _058_ sky130_fd_sc_hd__nor3_1
XFILLER_0_21_57 VPWR VGND VPWR VGND sky130_fd_sc_hd__decap_3
XFILLER_0_11_90 VPWR VGND VPWR VGND sky130_fd_sc_hd__decap_3
Xhold14 net21 add2.bit_add\[10\].fa.a VPWR VGND VGND VPWR sky130_fd_sc_hd__dlygate4sd3_1
XFILLER_0_21_137 VPWR VGND VPWR VGND sky130_fd_sc_hd__decap_3
XFILLER_0_32_12 VPWR VGND VPWR VGND sky130_fd_sc_hd__decap_3
XFILLER_0_4_304 VPWR VGND VPWR VGND sky130_fd_sc_hd__decap_3
XFILLER_0_12_115 VPWR VGND VPWR VGND sky130_fd_sc_hd__decap_3
XFILLER_0_12_159 VPWR VGND VPWR VGND sky130_fd_sc_hd__decap_3
XFILLER_0_32_6 VPWR VGND VPWR VGND sky130_fd_sc_hd__decap_3
XFILLER_0_7_175 VPWR VGND VPWR VGND sky130_fd_sc_hd__decap_3
XPHY_EDGE_ROW_1_Right_1 VPWR VGND VPWR VGND sky130_fd_sc_hd__decap_3
XFILLER_0_11_181 VPWR VGND VPWR VGND sky130_fd_sc_hd__decap_3
XFILLER_0_19_270 VPWR VGND VPWR VGND sky130_fd_sc_hd__decap_3
XFILLER_0_27_45 VPWR VGND VPWR VGND sky130_fd_sc_hd__decap_3
XFILLER_0_25_284 VPWR VGND VPWR VGND sky130_fd_sc_hd__decap_3
XFILLER_0_7_33 VPWR VGND VPWR VGND sky130_fd_sc_hd__decap_3
XFILLER_0_30_3 VPWR VGND VPWR VGND sky130_fd_sc_hd__decap_3
XFILLER_0_16_240 VPWR VGND VPWR VGND sky130_fd_sc_hd__decap_3
XANTENNA__502__RESET_B rst_n VGND VPWR VPWR VGND sky130_fd_sc_hd__diode_2
X_485_ prev[25] clknet_4_6_0_clk sync[25] VPWR VGND VPWR VGND sky130_fd_sc_hd__dfxtp_1
XFILLER_0_13_36 VPWR VGND VPWR VGND sky130_fd_sc_hd__decap_3
Xadd1.bit_add\[5\].fa.fa VPWR VGND VGND VPWR net1 add1.bit_add\[5\].fa.co add1.bit_add\[5\].fa.a
+ add1.bit_add\[4\].fa.co add1.bit_add\[5\].fa.sum sky130_fd_sc_hd__fa_1
XFILLER_0_13_276 VPWR VGND VPWR VGND sky130_fd_sc_hd__decap_3
Xg_delay.cg VGND VPWR g_delay.gclk g_delay.en clknet_4_5_0_clk VPWR VGND sky130_fd_sc_hd__dlclkp_1
XFILLER_0_13_287 VPWR VGND VPWR VGND sky130_fd_sc_hd__decap_3
X_270_ VGND VPWR VPWR VGND sync[16] pp.column\[0\].fa.b prev[16] sky130_fd_sc_hd__xor2_1
XFILLER_0_24_79 VPWR VGND VPWR VGND sky130_fd_sc_hd__decap_3
XFILLER_0_24_35 VPWR VGND VPWR VGND sky130_fd_sc_hd__decap_3
X_468_ prev[8] clknet_4_11_0_clk sync[8] VPWR VGND VPWR VGND sky130_fd_sc_hd__dfxtp_1
X_399_ VGND VPWR VPWR VGND clknet_4_5_0_clk valid[2] run_n valid[3] sky130_fd_sc_hd__dfrtp_2
XANTENNA__495__RESET_B rst_n VGND VPWR VPWR VGND sky130_fd_sc_hd__diode_2
XFILLER_0_4_12 VPWR VGND VPWR VGND sky130_fd_sc_hd__decap_3
XFILLER_0_10_246 VPWR VGND VPWR VGND sky130_fd_sc_hd__decap_3
XFILLER_0_33_305 VPWR VGND VPWR VGND sky130_fd_sc_hd__decap_3
Xpn.column\[3\].fa.fa VPWR VGND VGND VPWR pn.column\[3\].fa.b pn.column\[3\].fa.co
+ pn.column\[3\].fa.a pn.column\[3\].fa.ci pn.column\[3\].fa.sum sky130_fd_sc_hd__fa_1
XFILLER_0_5_284 VPWR VGND VPWR VGND sky130_fd_sc_hd__decap_3
X_322_ delay2[2] clknet_2_2__leaf_g_delay.gclk delay2[3] VPWR VGND VPWR VGND sky130_fd_sc_hd__dfxtp_1
X_253_ VPWR VGND VGND VPWR phase[1] _001_ _003_ sky130_fd_sc_hd__lpflow_isobufsrc_1
X_184_ VGND VPWR VPWR VGND _070_ delay2[0] history_valid sky130_fd_sc_hd__and2_0
XPHY_EDGE_ROW_24_Left_58 VPWR VGND VPWR VGND sky130_fd_sc_hd__decap_3
XFILLER_0_10_15 VPWR VGND VPWR VGND sky130_fd_sc_hd__decap_3
XFILLER_0_10_59 VPWR VGND VPWR VGND sky130_fd_sc_hd__decap_3
XFILLER_0_18_176 VPWR VGND VPWR VGND sky130_fd_sc_hd__decap_3
X_305_ delay1[6] clknet_2_3__leaf_g_delay.gclk delay1[7] VPWR VGND VPWR VGND sky130_fd_sc_hd__dfxtp_1
X_236_ VGND VPWR _077_ _099_ phase[4] VPWR VGND sky130_fd_sc_hd__xnor2_1
X_167_ VGND VPWR VGND VPWR _057_ capture sky130_fd_sc_hd__clkinv_8
XFILLER_0_27_9 VPWR VGND VPWR VGND sky130_fd_sc_hd__decap_3
XFILLER_0_1_57 VPWR VGND VPWR VGND sky130_fd_sc_hd__decap_3
XFILLER_0_15_113 VPWR VGND VPWR VGND sky130_fd_sc_hd__decap_3
Xhold15 net22 add2.bit_add\[8\].fa.a VPWR VGND VGND VPWR sky130_fd_sc_hd__dlygate4sd3_1
X_219_ VPWR VGND VGND VPWR dbg_mode[1] _093_ _094_ sky130_fd_sc_hd__nor2_1
XFILLER_0_32_24 VPWR VGND VPWR VGND sky130_fd_sc_hd__decap_3
XPHY_EDGE_ROW_27_Left_61 VPWR VGND VPWR VGND sky130_fd_sc_hd__decap_3
XFILLER_0_12_127 VPWR VGND VPWR VGND sky130_fd_sc_hd__decap_3
XPHY_EDGE_ROW_11_Left_45 VPWR VGND VPWR VGND sky130_fd_sc_hd__decap_3
Xclkbuf_0_tap_p[0] VGND VPWR tap_p[0] clknet_0_tap_p[0] VPWR VGND sky130_fd_sc_hd__clkbuf_4
XFILLER_0_11_193 VPWR VGND VPWR VGND sky130_fd_sc_hd__decap_3
Xclkbuf_0_clk VGND VPWR clk clknet_0_clk VPWR VGND sky130_fd_sc_hd__clkbuf_4
Xadd1.bit_add\[1\].fa.fa VPWR VGND VGND VPWR add1.bit_add\[1\].fa.b add1.bit_add\[1\].fa.co
+ add1.bit_add\[1\].fa.a add1.bit_add\[0\].fa.co add1.bit_add\[1\].fa.sum sky130_fd_sc_hd__fa_1
XFILLER_0_4_157 VPWR VGND VPWR VGND sky130_fd_sc_hd__decap_3
XFILLER_0_7_12 VPWR VGND VPWR VGND sky130_fd_sc_hd__decap_3
XPHY_EDGE_ROW_15_Right_15 VPWR VGND VPWR VGND sky130_fd_sc_hd__decap_3
XPHY_EDGE_ROW_24_Right_24 VPWR VGND VPWR VGND sky130_fd_sc_hd__decap_3
XFILLER_0_23_3 VPWR VGND VPWR VGND sky130_fd_sc_hd__decap_3
XPHY_EDGE_ROW_33_Right_33 VPWR VGND VPWR VGND sky130_fd_sc_hd__decap_3
XFILLER_0_31_277 VPWR VGND VPWR VGND sky130_fd_sc_hd__decap_3
XFILLER_0_3_190 VPWR VGND VPWR VGND sky130_fd_sc_hd__decap_3
Xpp.column\[2\].fa.fa VPWR VGND VGND VPWR pp.column\[2\].fa.b pp.column\[2\].fa.co
+ pp.column\[2\].fa.a pp.column\[2\].fa.ci pp.column\[2\].fa.sum sky130_fd_sc_hd__fa_1
X_484_ prev[24] clknet_4_2_0_clk sync[24] VPWR VGND VPWR VGND sky130_fd_sc_hd__dfxtp_1
XFILLER_0_13_15 VPWR VGND VPWR VGND sky130_fd_sc_hd__decap_3
XFILLER_0_13_48 VPWR VGND VPWR VGND sky130_fd_sc_hd__decap_3
XFILLER_0_22_277 VPWR VGND VPWR VGND sky130_fd_sc_hd__decap_3
XFILLER_0_13_299 VPWR VGND VPWR VGND sky130_fd_sc_hd__decap_3
XFILLER_0_0_182 VPWR VGND VPWR VGND sky130_fd_sc_hd__decap_3
XFILLER_0_0_193 VPWR VGND VPWR VGND sky130_fd_sc_hd__decap_3
X_398_ VGND VPWR VPWR VGND clknet_4_5_0_clk valid[1] run_n valid[2] sky130_fd_sc_hd__dfrtp_1
XFILLER_0_27_303 VPWR VGND VPWR VGND sky130_fd_sc_hd__decap_3
X_467_ prev[7] clknet_4_11_0_clk sync[7] VPWR VGND VPWR VGND sky130_fd_sc_hd__dfxtp_1
XFILLER_0_4_79 VPWR VGND VPWR VGND sky130_fd_sc_hd__decap_3
XFILLER_0_4_24 VPWR VGND VPWR VGND sky130_fd_sc_hd__decap_3
XFILLER_0_10_269 VPWR VGND VPWR VGND sky130_fd_sc_hd__decap_3
X_321_ delay2[1] clknet_2_2__leaf_g_delay.gclk delay2[2] VPWR VGND VPWR VGND sky130_fd_sc_hd__dfxtp_1
X_252_ VGND VPWR VPWR VGND vp.divided _114_[5] _106_ sky130_fd_sc_hd__xor2_1
X_183_ VPWR VGND VGND VPWR _069_ first sky130_fd_sc_hd__inv_1
XFILLER_0_10_38 VPWR VGND VPWR VGND sky130_fd_sc_hd__decap_3
XFILLER_0_19_69 VPWR VGND VPWR VGND sky130_fd_sc_hd__decap_3
Xadd1.bit_add\[16\].fa.fa VPWR VGND VGND VPWR add1.bit_add\[10\].fa.b add1.bit_add\[16\].fa.co
+ add1.bit_add\[16\].fa.a add1.bit_add\[15\].fa.co add1.bit_add\[16\].fa.sum sky130_fd_sc_hd__fa_1
XFILLER_0_30_309 VPWR VGND VPWR VGND sky130_fd_sc_hd__decap_3
X_235_ VPWR VGND VGND VPWR phase[4] _098_ _077_ sky130_fd_sc_hd__nand2_1
X_304_ delay1[5] clknet_2_3__leaf_g_delay.gclk delay1[6] VPWR VGND VPWR VGND sky130_fd_sc_hd__dfxtp_1
XFILLER_0_24_136 VPWR VGND VPWR VGND sky130_fd_sc_hd__decap_3
X_166_ sampled _055_ _051_ _049_ _057_ VPWR VGND VPWR VGND sky130_fd_sc_hd__nand4_4
XFILLER_0_12_309 VPWR VGND VPWR VGND sky130_fd_sc_hd__decap_3
XFILLER_0_30_128 VPWR VGND VPWR VGND sky130_fd_sc_hd__decap_3
XFILLER_0_11_81 VPWR VGND VPWR VGND sky130_fd_sc_hd__decap_3
Xhold16 net23 add2.bit_add\[12\].fa.a VPWR VGND VGND VPWR sky130_fd_sc_hd__dlygate4sd3_1
XFILLER_0_14_191 VPWR VGND VPWR VGND sky130_fd_sc_hd__decap_3
XFILLER_0_16_59 VPWR VGND VPWR VGND sky130_fd_sc_hd__decap_3
X_218_ VPWR VGND VGND VPWR dbg_mode[0] _093_ valid[3] sky130_fd_sc_hd__nand2_1
X_149_ VPWR VGND VGND VPWR _041_ _042_ _040_ rate sky130_fd_sc_hd__mux2i_1
XFILLER_0_12_106 VPWR VGND VPWR VGND sky130_fd_sc_hd__decap_3
Xadd1.bit_add\[0\].fa.fa_4 net4 add1.bit_add\[0\].fa.fa_4/HI VPWR VGND VGND VPWR sky130_fd_sc_hd__conb_1
XFILLER_0_18_6 VPWR VGND VPWR VGND sky130_fd_sc_hd__decap_3
XFILLER_0_11_150 VPWR VGND VPWR VGND sky130_fd_sc_hd__decap_3
XFILLER_0_9_9 VPWR VGND VPWR VGND sky130_fd_sc_hd__decap_3
XFILLER_0_11_172 VPWR VGND VPWR VGND sky130_fd_sc_hd__decap_3
XFILLER_0_4_136 VPWR VGND VPWR VGND sky130_fd_sc_hd__decap_3
XFILLER_0_4_125 VPWR VGND VPWR VGND sky130_fd_sc_hd__decap_3
XFILLER_0_16_3 VPWR VGND VPWR VGND sky130_fd_sc_hd__decap_3
XFILLER_0_7_6 VPWR VGND VPWR VGND sky130_fd_sc_hd__decap_3
X_483_ prev[23] clknet_4_3_0_clk sync[23] VPWR VGND VPWR VGND sky130_fd_sc_hd__dfxtp_1
XFILLER_0_13_27 VPWR VGND VPWR VGND sky130_fd_sc_hd__decap_3
Xbit_store\[15\].ff VPWR VGND work[15] clknet_1_1__leaf_g_work.gclk work[16] capture
+ net13 VPWR VGND sky130_fd_sc_hd__sdfxtp_1
XFILLER_0_5_3 VPWR VGND VPWR VGND sky130_fd_sc_hd__decap_3
X_397_ VGND VPWR VPWR VGND clknet_4_4_0_clk valid[0] run_n valid[1] sky130_fd_sc_hd__dfrtp_1
X_466_ prev[6] clknet_4_11_0_clk sync[6] VPWR VGND VPWR VGND sky130_fd_sc_hd__dfxtp_1
Xadd1.bit_add\[12\].fa.fa VPWR VGND VGND VPWR net1 add1.bit_add\[12\].fa.co add1.bit_add\[12\].fa.a
+ add1.bit_add\[11\].fa.co add1.bit_add\[12\].fa.sum sky130_fd_sc_hd__fa_1
XFILLER_0_30_91 VPWR VGND VPWR VGND sky130_fd_sc_hd__decap_3
X_182_ VPWR VGND _069_ _067_ net30 VPWR VGND sky130_fd_sc_hd__xor2_2
X_320_ delay2[0] clknet_2_2__leaf_g_delay.gclk delay2[1] VPWR VGND VPWR VGND sky130_fd_sc_hd__dfxtp_1
X_251_ VGND VPWR _104_ _114_[4] vp.count[4] VPWR VGND sky130_fd_sc_hd__xnor2_1
XFILLER_0_19_15 VPWR VGND VPWR VGND sky130_fd_sc_hd__decap_3
Xbit_store\[2\].ff VPWR VGND shift_word[1] clknet_1_0__leaf_g_work.gclk work[3] capture
+ net17 VPWR VGND sky130_fd_sc_hd__sdfxtp_1
X_449_ sync[19] clknet_4_0_0_clk meta[19] VPWR VGND VPWR VGND sky130_fd_sc_hd__dfxtp_1
XFILLER_0_15_307 VPWR VGND VPWR VGND sky130_fd_sc_hd__decap_3
XFILLER_0_18_167 VPWR VGND VPWR VGND sky130_fd_sc_hd__decap_3
XFILLER_0_33_148 VPWR VGND VPWR VGND sky130_fd_sc_hd__decap_3
X_234_ VPWR VGND VGND VPWR _077_ _075_ _061_ _002_[3] sky130_fd_sc_hd__nor3_1
X_303_ delay1[4] clknet_2_1__leaf_g_delay.gclk delay1[5] VPWR VGND VPWR VGND sky130_fd_sc_hd__dfxtp_1
X_165_ VPWR VGND VPWR VGND phase[7] phase[4] phase[5] phase[6] _056_ sky130_fd_sc_hd__or4_1
XFILLER_0_32_192 VPWR VGND VPWR VGND sky130_fd_sc_hd__decap_3
XFILLER_0_11_60 VPWR VGND VPWR VGND sky130_fd_sc_hd__decap_3
XFILLER_0_11_93 VPWR VGND VPWR VGND sky130_fd_sc_hd__decap_3
Xhold17 net24 add2.bit_add\[9\].fa.a VPWR VGND VGND VPWR sky130_fd_sc_hd__dlygate4sd3_1
XFILLER_0_32_15 VPWR VGND VPWR VGND sky130_fd_sc_hd__decap_3
X_217_ VGND VPWR VGND VPWR _013_ _092_ add1.bit_add\[10\].fa.b pp.f5.co sky130_fd_sc_hd__a21oi_4
X_148_ VPWR VGND VPWR VGND work[6] _026_ _041_ work[5] _025_ sky130_fd_sc_hd__a22oi_1
XFILLER_0_12_118 VPWR VGND VPWR VGND sky130_fd_sc_hd__decap_3
XFILLER_0_32_9 VPWR VGND VPWR VGND sky130_fd_sc_hd__decap_3
XFILLER_0_7_178 VPWR VGND VPWR VGND sky130_fd_sc_hd__decap_3
XFILLER_0_11_162 VPWR VGND VPWR VGND sky130_fd_sc_hd__decap_3
XFILLER_0_11_184 VPWR VGND VPWR VGND sky130_fd_sc_hd__decap_3
XFILLER_0_19_273 VPWR VGND VPWR VGND sky130_fd_sc_hd__decap_3
XFILLER_0_27_48 VPWR VGND VPWR VGND sky130_fd_sc_hd__decap_3
XFILLER_0_7_36 VPWR VGND VPWR VGND sky130_fd_sc_hd__decap_3
XFILLER_0_30_6 VPWR VGND VPWR VGND sky130_fd_sc_hd__decap_3
XPHY_EDGE_ROW_5_Right_5 VPWR VGND VPWR VGND sky130_fd_sc_hd__decap_3
XFILLER_0_16_243 VPWR VGND VPWR VGND sky130_fd_sc_hd__decap_3
XFILLER_0_3_181 VPWR VGND VPWR VGND sky130_fd_sc_hd__decap_3
X_482_ prev[22] clknet_4_3_0_clk sync[22] VPWR VGND VPWR VGND sky130_fd_sc_hd__dfxtp_1
XFILLER_0_13_39 VPWR VGND VPWR VGND sky130_fd_sc_hd__decap_3
XFILLER_0_30_290 VPWR VGND VPWR VGND sky130_fd_sc_hd__decap_3
XFILLER_0_0_173 VPWR VGND VPWR VGND sky130_fd_sc_hd__decap_3
XFILLER_0_28_80 VPWR VGND VPWR VGND sky130_fd_sc_hd__decap_3
XFILLER_0_8_262 VPWR VGND VPWR VGND sky130_fd_sc_hd__decap_3
XFILLER_0_24_38 VPWR VGND VPWR VGND sky130_fd_sc_hd__decap_3
X_465_ prev[5] clknet_4_10_0_clk sync[5] VPWR VGND VPWR VGND sky130_fd_sc_hd__dfxtp_1
X_396_ VGND VPWR VPWR VGND clknet_4_5_0_clk net6 run_n valid[0] sky130_fd_sc_hd__dfrtp_1
XFILLER_0_4_15 VPWR VGND VPWR VGND sky130_fd_sc_hd__decap_3
XFILLER_0_10_205 VPWR VGND VPWR VGND sky130_fd_sc_hd__decap_3
XFILLER_0_10_249 VPWR VGND VPWR VGND sky130_fd_sc_hd__decap_3
XFILLER_0_30_81 VPWR VGND VPWR VGND sky130_fd_sc_hd__decap_3
XFILLER_0_5_287 VPWR VGND VPWR VGND sky130_fd_sc_hd__decap_3
XFILLER_0_5_221 VPWR VGND VPWR VGND sky130_fd_sc_hd__decap_3
Xadd2.bit_add\[8\].fa.fa VPWR VGND VGND VPWR add1.bit_add\[8\].fa.a add2.bit_add\[8\].fa.co
+ add2.bit_add\[8\].fa.a add2.bit_add\[7\].fa.co add2.bit_add\[8\].fa.sum sky130_fd_sc_hd__fa_1
X_181_ VPWR VGND VGND VPWR _068_ _063_ _006_ _064_ borrow1 sky130_fd_sc_hd__o2bb2ai_1
XFILLER_0_10_18 VPWR VGND VPWR VGND sky130_fd_sc_hd__decap_3
X_250_ VPWR VGND VGND VPWR vp.count[4] _104_ _106_ sky130_fd_sc_hd__lpflow_isobufsrc_1
XFILLER_0_10_29 VPWR VGND VPWR VGND sky130_fd_sc_hd__decap_3
X_448_ sync[18] clknet_4_1_0_clk meta[18] VPWR VGND VPWR VGND sky130_fd_sc_hd__dfxtp_1
X_379_ VGND VPWR VPWR VGND clknet_4_15_0_clk add2.bit_add\[6\].fa.sum net2 add2.bit_add\[6\].fa.a
+ sky130_fd_sc_hd__dfrtp_1
XFILLER_0_2_257 VPWR VGND VPWR VGND sky130_fd_sc_hd__decap_3
XFILLER_0_18_179 VPWR VGND VPWR VGND sky130_fd_sc_hd__decap_3
X_302_ delay1[3] clknet_2_3__leaf_g_delay.gclk delay1[4] VPWR VGND VPWR VGND sky130_fd_sc_hd__dfxtp_1
X_164_ VGND VPWR VGND VPWR phase[1] phase[2] phase[3] _055_ phase[0] sky130_fd_sc_hd__nor4b_2
X_233_ VPWR VGND VGND VPWR _097_ _075_ _060_ _002_[2] sky130_fd_sc_hd__nor3_1
XFILLER_0_23_160 VPWR VGND VPWR VGND sky130_fd_sc_hd__decap_3
XFILLER_0_11_72 VPWR VGND VPWR VGND sky130_fd_sc_hd__decap_3
XFILLER_0_11_311 VPWR VGND VPWR VGND sky130_fd_sc_hd__decap_3
Xhold18 net25 add2.bit_add\[0\].fa.a VPWR VGND VGND VPWR sky130_fd_sc_hd__dlygate4sd3_1
XANTENNA__505__RESET_B rst_n VGND VPWR VPWR VGND sky130_fd_sc_hd__diode_2
X_216_ VPWR VGND VPWR VGND _091_ _090_ _092_ add1.bit_add\[3\].fa.b sky130_fd_sc_hd__a21oi_1
X_147_ VPWR VGND VPWR VGND work[8] _026_ _040_ work[7] _025_ sky130_fd_sc_hd__a22oi_1
XFILLER_0_11_141 VPWR VGND VPWR VGND sky130_fd_sc_hd__decap_3
XFILLER_0_11_196 VPWR VGND VPWR VGND sky130_fd_sc_hd__decap_3
XFILLER_0_6_190 VPWR VGND VPWR VGND sky130_fd_sc_hd__decap_3
XFILLER_0_25_200 VPWR VGND VPWR VGND sky130_fd_sc_hd__decap_3
XPHY_EDGE_ROW_15_Left_49 VPWR VGND VPWR VGND sky130_fd_sc_hd__decap_3
XANTENNA__498__RESET_B rst_n VGND VPWR VPWR VGND sky130_fd_sc_hd__diode_2
XFILLER_0_23_6 VPWR VGND VPWR VGND sky130_fd_sc_hd__decap_3
XFILLER_0_33_70 VPWR VGND VPWR VGND sky130_fd_sc_hd__decap_3
XFILLER_0_17_93 VPWR VGND VPWR VGND sky130_fd_sc_hd__decap_3
XFILLER_0_3_193 VPWR VGND VPWR VGND sky130_fd_sc_hd__decap_3
X_481_ prev[21] clknet_4_0_0_clk sync[21] VPWR VGND VPWR VGND sky130_fd_sc_hd__dfxtp_1
XPHY_EDGE_ROW_11_Right_11 VPWR VGND VPWR VGND sky130_fd_sc_hd__decap_3
XFILLER_0_13_18 VPWR VGND VPWR VGND sky130_fd_sc_hd__decap_3
XPHY_EDGE_ROW_20_Right_20 VPWR VGND VPWR VGND sky130_fd_sc_hd__decap_3
XFILLER_0_13_225 VPWR VGND VPWR VGND sky130_fd_sc_hd__decap_3
Xpp.f2.fa VPWR VGND VGND VPWR pp.column\[1\].fa.co pp.f2.co pp.column\[0\].fa.co pp.column\[2\].fa.co
+ pp.f2.sum sky130_fd_sc_hd__fa_1
XFILLER_0_21_3 VPWR VGND VPWR VGND sky130_fd_sc_hd__decap_3
Xadd2.bit_add\[4\].fa.fa VPWR VGND VGND VPWR add1.bit_add\[4\].fa.a add2.bit_add\[4\].fa.co
+ add2.bit_add\[4\].fa.a add2.bit_add\[3\].fa.co add2.bit_add\[4\].fa.sum sky130_fd_sc_hd__fa_1
XFILLER_0_27_306 VPWR VGND VPWR VGND sky130_fd_sc_hd__decap_3
X_464_ prev[4] clknet_4_8_0_clk sync[4] VPWR VGND VPWR VGND sky130_fd_sc_hd__dfxtp_1
X_395_ VGND VPWR VPWR VGND clknet_4_13_0_clk _010_ run_n sampled sky130_fd_sc_hd__dfrtp_4
XFILLER_0_33_309 VPWR VGND VPWR VGND sky130_fd_sc_hd__decap_3
XFILLER_0_14_50 VPWR VGND VPWR VGND sky130_fd_sc_hd__decap_3
XPHY_EDGE_ROW_18_Left_52 VPWR VGND VPWR VGND sky130_fd_sc_hd__decap_3
X_180_ VPWR VGND VPWR VGND _067_ borrow1 _066_ _068_ sky130_fd_sc_hd__a21oi_1
XFILLER_0_24_309 VPWR VGND VPWR VGND sky130_fd_sc_hd__decap_3
Xclkbuf_2_2__f_g_delay.gclk VGND VPWR clknet_0_g_delay.gclk clknet_2_2__leaf_g_delay.gclk
+ VPWR VGND sky130_fd_sc_hd__clkbuf_4
XFILLER_0_27_169 VPWR VGND VPWR VGND sky130_fd_sc_hd__decap_3
X_378_ VGND VPWR VPWR VGND clknet_4_15_0_clk add2.bit_add\[5\].fa.sum net2 add2.bit_add\[5\].fa.a
+ sky130_fd_sc_hd__dfrtp_1
X_447_ sync[17] clknet_4_0_0_clk meta[17] VPWR VGND VPWR VGND sky130_fd_sc_hd__dfxtp_1
XPHY_EDGE_ROW_3_Left_37 VPWR VGND VPWR VGND sky130_fd_sc_hd__decap_3
X_232_ VPWR VGND VPWR VGND phase[1] phase[0] phase[2] _097_ sky130_fd_sc_hd__a21oi_1
X_301_ delay1[2] clknet_2_3__leaf_g_delay.gclk delay1[3] VPWR VGND VPWR VGND sky130_fd_sc_hd__dfxtp_1
X_163_ VGND VPWR VPWR VGND _050_ _044_ _037_ _005_ _054_ sky130_fd_sc_hd__a31oi_1
XFILLER_0_20_312 VPWR VGND VPWR VGND sky130_fd_sc_hd__decap_3
XFILLER_0_11_51 VPWR VGND VPWR VGND sky130_fd_sc_hd__decap_3
XFILLER_0_23_172 VPWR VGND VPWR VGND sky130_fd_sc_hd__decap_3
XFILLER_0_11_84 VPWR VGND VPWR VGND sky130_fd_sc_hd__decap_3
Xhold19 net26 add2.bit_add\[7\].fa.a VPWR VGND VGND VPWR sky130_fd_sc_hd__dlygate4sd3_1
X_215_ VGND VPWR valid[3] _090_ _092_ _091_ VPWR VGND sky130_fd_sc_hd__o21ai_2
XFILLER_0_4_309 VPWR VGND VPWR VGND sky130_fd_sc_hd__decap_3
X_146_ VGND VPWR VPWR VGND _039_ _038_ phase[3] sky130_fd_sc_hd__and2_0
XFILLER_0_12_109 VPWR VGND VPWR VGND sky130_fd_sc_hd__decap_3
XFILLER_0_18_9 VPWR VGND VPWR VGND sky130_fd_sc_hd__decap_3
XFILLER_0_7_169 VPWR VGND VPWR VGND sky130_fd_sc_hd__decap_3
Xbit_store\[18\].ff VPWR VGND work[18] clknet_1_0__leaf_g_work.gclk work[19] capture
+ net15 VPWR VGND sky130_fd_sc_hd__sdfxtp_1
Xpp.f5.fa VPWR VGND VGND VPWR pp.f2.co pp.f5.co pp.f3.co pp.f4.co pp.f5.sum sky130_fd_sc_hd__fa_2
XFILLER_0_11_153 VPWR VGND VPWR VGND sky130_fd_sc_hd__decap_3
XFILLER_0_11_175 VPWR VGND VPWR VGND sky130_fd_sc_hd__decap_3
XPHY_EDGE_ROW_6_Left_40 VPWR VGND VPWR VGND sky130_fd_sc_hd__decap_3
XFILLER_0_25_212 VPWR VGND VPWR VGND sky130_fd_sc_hd__decap_3
XFILLER_0_4_128 VPWR VGND VPWR VGND sky130_fd_sc_hd__decap_3
X_129_ VGND VPWR VPWR VGND rate _022_ phase[3] sky130_fd_sc_hd__xor2_1
XFILLER_0_0_312 VPWR VGND VPWR VGND sky130_fd_sc_hd__decap_3
XFILLER_0_33_60 VPWR VGND VPWR VGND sky130_fd_sc_hd__decap_3
XFILLER_0_3_172 VPWR VGND VPWR VGND sky130_fd_sc_hd__decap_3
XFILLER_0_3_150 VPWR VGND VPWR VGND sky130_fd_sc_hd__decap_3
XFILLER_0_7_9 VPWR VGND VPWR VGND sky130_fd_sc_hd__decap_3
XPHY_EDGE_ROW_32_Left_66 VPWR VGND VPWR VGND sky130_fd_sc_hd__decap_3
Xadd2.bit_add\[0\].fa.fa VPWR VGND VGND VPWR add1.bit_add\[0\].fa.a add2.bit_add\[0\].fa.co
+ add2.bit_add\[0\].fa.a net5 add2.bit_add\[0\].fa.sum sky130_fd_sc_hd__fa_1
X_480_ prev[20] clknet_4_0_0_clk sync[20] VPWR VGND VPWR VGND sky130_fd_sc_hd__dfxtp_1
XFILLER_0_30_281 VPWR VGND VPWR VGND sky130_fd_sc_hd__decap_3
XANTENNA__492__D osr_sel VGND VPWR VPWR VGND sky130_fd_sc_hd__diode_2
Xbit_store\[5\].ff VPWR VGND work[5] clknet_1_1__leaf_g_work.gclk work[6] capture
+ net27 VPWR VGND sky130_fd_sc_hd__sdfxtp_1
XFILLER_0_5_6 VPWR VGND VPWR VGND sky130_fd_sc_hd__decap_3
XFILLER_0_8_92 VPWR VGND VPWR VGND sky130_fd_sc_hd__decap_3
XFILLER_0_12_292 VPWR VGND VPWR VGND sky130_fd_sc_hd__decap_3
XANTENNA__220__A dbg_mode[1] VGND VPWR VPWR VGND sky130_fd_sc_hd__diode_2
X_394_ VGND VPWR VPWR VGND _000_ run_n cic_n clknet_4_13_0_clk sky130_fd_sc_hd__dfrtn_1
XFILLER_0_24_29 VPWR VGND VPWR VGND sky130_fd_sc_hd__decap_3
X_463_ prev[3] clknet_4_8_0_clk sync[3] VPWR VGND VPWR VGND sky130_fd_sc_hd__dfxtp_1
XFILLER_0_5_201 VPWR VGND VPWR VGND sky130_fd_sc_hd__decap_3
XFILLER_0_30_94 VPWR VGND VPWR VGND sky130_fd_sc_hd__decap_3
XFILLER_0_30_72 VPWR VGND VPWR VGND sky130_fd_sc_hd__decap_3
XFILLER_0_3_3 VPWR VGND VPWR VGND sky130_fd_sc_hd__decap_3
X_446_ sync[16] clknet_4_0_0_clk meta[16] VPWR VGND VPWR VGND sky130_fd_sc_hd__dfxtp_1
X_377_ VGND VPWR VPWR VGND clknet_4_12_0_clk add2.bit_add\[4\].fa.sum cic_n add2.bit_add\[4\].fa.a
+ sky130_fd_sc_hd__dfrtp_1
XFILLER_0_23_310 VPWR VGND VPWR VGND sky130_fd_sc_hd__decap_3
XFILLER_0_33_107 VPWR VGND VPWR VGND sky130_fd_sc_hd__decap_3
XFILLER_0_26_170 VPWR VGND VPWR VGND sky130_fd_sc_hd__decap_3
X_231_ VPWR VGND VGND VPWR _075_ _096_ _002_[1] sky130_fd_sc_hd__nor2_1
X_300_ delay1[1] clknet_2_3__leaf_g_delay.gclk delay1[2] VPWR VGND VPWR VGND sky130_fd_sc_hd__dfxtp_1
X_162_ VPWR VGND VPWR VGND sdo _001_ _054_ _036_ sky130_fd_sc_hd__o21bai_1
X_429_ meta[29] clknet_4_3_0_clk tap_p[14] VPWR VGND VPWR VGND sky130_fd_sc_hd__dfxtp_1
XFILLER_0_11_30 VPWR VGND VPWR VGND sky130_fd_sc_hd__decap_3
XFILLER_0_11_63 VPWR VGND VPWR VGND sky130_fd_sc_hd__decap_3
XFILLER_0_11_96 VPWR VGND VPWR VGND sky130_fd_sc_hd__decap_3
XFILLER_0_11_302 VPWR VGND VPWR VGND sky130_fd_sc_hd__decap_3
XFILLER_0_32_18 VPWR VGND VPWR VGND sky130_fd_sc_hd__decap_3
X_214_ VGND VPWR VPWR VGND pp.f5.co _091_ pn.f5.co sky130_fd_sc_hd__xor2_1
X_145_ VGND VPWR VGND VPWR work[6] work[4] rate work[5] work[3] phase[2] _038_ sky130_fd_sc_hd__mux4_1
XFILLER_0_11_165 VPWR VGND VPWR VGND sky130_fd_sc_hd__decap_3
XFILLER_0_11_187 VPWR VGND VPWR VGND sky130_fd_sc_hd__decap_3
XFILLER_0_19_276 VPWR VGND VPWR VGND sky130_fd_sc_hd__decap_3
XFILLER_0_33_290 VPWR VGND VPWR VGND sky130_fd_sc_hd__decap_3
X_128_ VPWR VGND VGND VPWR rate phase[3] _021_ sky130_fd_sc_hd__nand2b_1
XFILLER_0_30_9 VPWR VGND VPWR VGND sky130_fd_sc_hd__decap_3
XFILLER_0_16_246 VPWR VGND VPWR VGND sky130_fd_sc_hd__decap_3
XFILLER_0_3_184 VPWR VGND VPWR VGND sky130_fd_sc_hd__decap_3
XFILLER_0_3_162 VPWR VGND VPWR VGND sky130_fd_sc_hd__decap_3
XANTENNA__218__A dbg_mode[0] VGND VPWR VPWR VGND sky130_fd_sc_hd__diode_2
XFILLER_0_30_293 VPWR VGND VPWR VGND sky130_fd_sc_hd__decap_3
XPHY_EDGE_ROW_9_Right_9 VPWR VGND VPWR VGND sky130_fd_sc_hd__decap_3
XFILLER_0_0_176 VPWR VGND VPWR VGND sky130_fd_sc_hd__decap_3
XFILLER_0_0_187 VPWR VGND VPWR VGND sky130_fd_sc_hd__decap_3
XFILLER_0_8_71 VPWR VGND VPWR VGND sky130_fd_sc_hd__decap_3
X_462_ prev[2] clknet_4_9_0_clk sync[2] VPWR VGND VPWR VGND sky130_fd_sc_hd__dfxtp_1
X_393_ VGND VPWR VPWR VGND clknet_4_4_0_clk add2.bit_add\[20\].fa.sum net3 add2.bit_add\[20\].fa.a
+ sky130_fd_sc_hd__dfrtp_1
XFILLER_0_4_18 VPWR VGND VPWR VGND sky130_fd_sc_hd__decap_3
XFILLER_0_14_41 VPWR VGND VPWR VGND sky130_fd_sc_hd__decap_3
XFILLER_0_32_300 VPWR VGND VPWR VGND sky130_fd_sc_hd__decap_3
X_376_ VGND VPWR VPWR VGND clknet_4_12_0_clk add2.bit_add\[3\].fa.sum cic_n add2.bit_add\[3\].fa.a
+ sky130_fd_sc_hd__dfrtp_1
X_445_ sync[15] clknet_4_0_0_clk meta[15] VPWR VGND VPWR VGND sky130_fd_sc_hd__dfxtp_1
XFILLER_0_25_73 VPWR VGND VPWR VGND sky130_fd_sc_hd__decap_3
X_161_ VPWR VGND VGND VPWR sampled _001_ _053_ sky130_fd_sc_hd__nand2_1
X_230_ VGND VPWR phase[1] _096_ phase[0] VPWR VGND sky130_fd_sc_hd__xnor2_1
XFILLER_0_24_108 VPWR VGND VPWR VGND sky130_fd_sc_hd__decap_3
X_428_ meta[28] clknet_4_2_0_clk tap_p[13] VPWR VGND VPWR VGND sky130_fd_sc_hd__dfxtp_1
XFILLER_0_23_163 VPWR VGND VPWR VGND sky130_fd_sc_hd__decap_3
XFILLER_0_11_42 VPWR VGND VPWR VGND sky130_fd_sc_hd__decap_3
XFILLER_0_11_75 VPWR VGND VPWR VGND sky130_fd_sc_hd__decap_3
XFILLER_0_11_314 VPWR VGND VPWR VGND sky130_fd_sc_hd__decap_3
X_359_ VGND VPWR VPWR VGND clknet_4_14_0_clk add1.bit_add\[7\].fa.sum net2 add1.bit_add\[7\].fa.a
+ sky130_fd_sc_hd__dfrtp_1
XFILLER_0_14_141 VPWR VGND VPWR VGND sky130_fd_sc_hd__decap_3
Xpn.f2.fa VPWR VGND VGND VPWR pn.column\[1\].fa.co pn.f2.co pn.column\[0\].fa.co pn.column\[2\].fa.co
+ pn.f2.sum sky130_fd_sc_hd__fa_1
X_213_ VPWR VGND VGND VPWR _090_ _087_ _011_ pn.f5.sum sky130_fd_sc_hd__maj3_1
X_144_ VGND VPWR _037_ _035_ _030_ _036_ VPWR VGND sky130_fd_sc_hd__and3_1
XFILLER_0_20_155 VPWR VGND VPWR VGND sky130_fd_sc_hd__decap_3
XFILLER_0_3_311 VPWR VGND VPWR VGND sky130_fd_sc_hd__decap_3
XFILLER_0_11_122 VPWR VGND VPWR VGND sky130_fd_sc_hd__decap_3
XFILLER_0_11_144 VPWR VGND VPWR VGND sky130_fd_sc_hd__decap_3
XFILLER_0_11_199 VPWR VGND VPWR VGND sky130_fd_sc_hd__decap_3
XFILLER_0_6_193 VPWR VGND VPWR VGND sky130_fd_sc_hd__decap_3
XFILLER_0_25_203 VPWR VGND VPWR VGND sky130_fd_sc_hd__decap_3
X_127_ VPWR VGND VGND VPWR phase[3] rate _020_ sky130_fd_sc_hd__nand2b_1
XFILLER_0_23_9 VPWR VGND VPWR VGND sky130_fd_sc_hd__decap_3
XFILLER_0_33_73 VPWR VGND VPWR VGND sky130_fd_sc_hd__decap_3
XFILLER_0_16_269 VPWR VGND VPWR VGND sky130_fd_sc_hd__decap_3
XFILLER_0_13_228 VPWR VGND VPWR VGND sky130_fd_sc_hd__decap_3
XFILLER_0_21_272 VPWR VGND VPWR VGND sky130_fd_sc_hd__decap_3
XFILLER_0_8_50 VPWR VGND VPWR VGND sky130_fd_sc_hd__decap_3
X_461_ prev[1] clknet_4_9_0_clk sync[1] VPWR VGND VPWR VGND sky130_fd_sc_hd__dfxtp_1
XFILLER_0_27_309 VPWR VGND VPWR VGND sky130_fd_sc_hd__decap_3
X_392_ VGND VPWR VPWR VGND clknet_4_6_0_clk add2.bit_add\[19\].fa.sum net3 add2.bit_add\[19\].fa.a
+ sky130_fd_sc_hd__dfrtp_1
XFILLER_0_14_53 VPWR VGND VPWR VGND sky130_fd_sc_hd__decap_3
XFILLER_0_18_309 VPWR VGND VPWR VGND sky130_fd_sc_hd__decap_3
XFILLER_0_30_85 VPWR VGND VPWR VGND sky130_fd_sc_hd__decap_3
XFILLER_0_29_191 VPWR VGND VPWR VGND sky130_fd_sc_hd__decap_3
XFILLER_0_32_312 VPWR VGND VPWR VGND sky130_fd_sc_hd__decap_3
Xpn.f5.fa VPWR VGND VGND VPWR pn.f2.co pn.f5.co pn.f3.co pn.f4.co pn.f5.sum sky130_fd_sc_hd__fa_2
X_444_ sync[14] clknet_4_10_0_clk meta[14] VPWR VGND VPWR VGND sky130_fd_sc_hd__dfxtp_1
X_375_ VGND VPWR VPWR VGND clknet_4_4_0_clk add2.bit_add\[2\].fa.sum net3 add2.bit_add\[2\].fa.a
+ sky130_fd_sc_hd__dfrtp_1
XFILLER_0_14_312 VPWR VGND VPWR VGND sky130_fd_sc_hd__decap_3
X_160_ VPWR VGND VPWR VGND _051_ phase[5] _052_ _053_ sky130_fd_sc_hd__a21o_1
X_427_ meta[27] clknet_4_3_0_clk tap_p[12] VPWR VGND VPWR VGND sky130_fd_sc_hd__dfxtp_1
X_358_ VGND VPWR VPWR VGND clknet_4_14_0_clk add1.bit_add\[6\].fa.sum net2 add1.bit_add\[6\].fa.a
+ sky130_fd_sc_hd__dfrtp_1
XFILLER_0_11_87 VPWR VGND VPWR VGND sky130_fd_sc_hd__decap_3
X_289_ VGND VPWR VPWR VGND vn.count[2] vn.count[1] vn.count[0] _109_ vn.count[3] sky130_fd_sc_hd__a31oi_1
XPHY_EDGE_ROW_18_Right_18 VPWR VGND VPWR VGND sky130_fd_sc_hd__decap_3
XPHY_EDGE_ROW_27_Right_27 VPWR VGND VPWR VGND sky130_fd_sc_hd__decap_3
XFILLER_0_14_131 VPWR VGND VPWR VGND sky130_fd_sc_hd__decap_3
X_212_ VGND VPWR VPWR VGND add1.bit_add\[2\].fa.b _089_ valid[3] sky130_fd_sc_hd__and2_0
Xclkbuf_1_1__f_tap_p[0] VGND VPWR clknet_0_tap_p[0] clknet_1_1__leaf_tap_p[0] VPWR
+ VGND sky130_fd_sc_hd__clkbuf_4
X_143_ VPWR VGND VGND VPWR phase[0] phase[1] _036_ sky130_fd_sc_hd__nor2_1
Xbit_store\[8\].ff VPWR VGND work[8] clknet_1_1__leaf_g_work.gclk work[9] capture
+ net22 VPWR VGND sky130_fd_sc_hd__sdfxtp_1
XFILLER_0_11_156 VPWR VGND VPWR VGND sky130_fd_sc_hd__decap_3
XFILLER_0_11_178 VPWR VGND VPWR VGND sky130_fd_sc_hd__decap_3
XFILLER_0_2_85 VPWR VGND VPWR VGND sky130_fd_sc_hd__decap_3
Xadd2.bit_add\[16\].fa.fa VPWR VGND VGND VPWR add1.bit_add\[16\].fa.a add2.bit_add\[16\].fa.co
+ add2.bit_add\[16\].fa.a add2.bit_add\[15\].fa.co add2.bit_add\[16\].fa.sum sky130_fd_sc_hd__fa_1
XFILLER_0_19_267 VPWR VGND VPWR VGND sky130_fd_sc_hd__decap_3
XFILLER_0_33_281 VPWR VGND VPWR VGND sky130_fd_sc_hd__decap_3
X_126_ VPWR VGND VGND VPWR phase[5] phase[4] _019_ sky130_fd_sc_hd__lpflow_isobufsrc_1
XFILLER_0_17_64 VPWR VGND VPWR VGND sky130_fd_sc_hd__decap_3
XFILLER_0_33_63 VPWR VGND VPWR VGND sky130_fd_sc_hd__decap_3
XFILLER_0_3_153 VPWR VGND VPWR VGND sky130_fd_sc_hd__decap_3
XFILLER_0_16_237 VPWR VGND VPWR VGND sky130_fd_sc_hd__decap_3
XFILLER_0_3_175 VPWR VGND VPWR VGND sky130_fd_sc_hd__decap_3
XPHY_EDGE_ROW_0_Right_0 VPWR VGND VPWR VGND sky130_fd_sc_hd__decap_3
XFILLER_0_30_284 VPWR VGND VPWR VGND sky130_fd_sc_hd__decap_3
XFILLER_0_0_145 VPWR VGND VPWR VGND sky130_fd_sc_hd__decap_3
XFILLER_0_28_74 VPWR VGND VPWR VGND sky130_fd_sc_hd__decap_3
XFILLER_0_8_245 VPWR VGND VPWR VGND sky130_fd_sc_hd__decap_3
XFILLER_0_8_62 VPWR VGND VPWR VGND sky130_fd_sc_hd__decap_3
XFILLER_0_8_95 VPWR VGND VPWR VGND sky130_fd_sc_hd__decap_3
XFILLER_0_12_262 VPWR VGND VPWR VGND sky130_fd_sc_hd__decap_3
XFILLER_0_5_9 VPWR VGND VPWR VGND sky130_fd_sc_hd__decap_3
XFILLER_0_12_295 VPWR VGND VPWR VGND sky130_fd_sc_hd__decap_3
X_460_ prev[0] clknet_4_9_0_clk sync[0] VPWR VGND VPWR VGND sky130_fd_sc_hd__dfxtp_1
X_391_ VGND VPWR VPWR VGND clknet_4_6_0_clk add2.bit_add\[18\].fa.sum net3 add2.bit_add\[18\].fa.a
+ sky130_fd_sc_hd__dfrtp_1
XFILLER_0_14_32 VPWR VGND VPWR VGND sky130_fd_sc_hd__decap_3
XFILLER_0_30_97 VPWR VGND VPWR VGND sky130_fd_sc_hd__decap_3
XFILLER_0_30_75 VPWR VGND VPWR VGND sky130_fd_sc_hd__decap_3
XFILLER_0_12_3 VPWR VGND VPWR VGND sky130_fd_sc_hd__decap_3
XFILLER_0_3_6 VPWR VGND VPWR VGND sky130_fd_sc_hd__decap_3
X_374_ VGND VPWR VPWR VGND clknet_4_7_0_clk add2.bit_add\[1\].fa.sum net3 add2.bit_add\[1\].fa.a
+ sky130_fd_sc_hd__dfrtp_1
X_443_ sync[13] clknet_4_11_0_clk meta[13] VPWR VGND VPWR VGND sky130_fd_sc_hd__dfxtp_1
XFILLER_0_23_313 VPWR VGND VPWR VGND sky130_fd_sc_hd__decap_3
Xadd1.bit_add\[8\].fa.fa VPWR VGND VGND VPWR net1 add1.bit_add\[8\].fa.co add1.bit_add\[8\].fa.a
+ add1.bit_add\[7\].fa.co add1.bit_add\[8\].fa.sum sky130_fd_sc_hd__fa_1
XFILLER_0_26_173 VPWR VGND VPWR VGND sky130_fd_sc_hd__decap_3
XFILLER_0_14_302 VPWR VGND VPWR VGND sky130_fd_sc_hd__decap_3
XFILLER_0_5_30 VPWR VGND VPWR VGND sky130_fd_sc_hd__decap_3
XFILLER_0_1_273 VPWR VGND VPWR VGND sky130_fd_sc_hd__decap_3
Xclkbuf_1_0__f_tap_p[0] VGND VPWR clknet_0_tap_p[0] clknet_1_0__leaf_tap_p[0] VPWR
+ VGND sky130_fd_sc_hd__clkbuf_4
XFILLER_0_1_3 VPWR VGND VPWR VGND sky130_fd_sc_hd__decap_3
X_357_ VGND VPWR VPWR VGND clknet_4_15_0_clk add1.bit_add\[5\].fa.sum cic_n add1.bit_add\[5\].fa.a
+ sky130_fd_sc_hd__dfrtp_1
X_426_ meta[26] clknet_4_3_0_clk tap_p[11] VPWR VGND VPWR VGND sky130_fd_sc_hd__dfxtp_1
XFILLER_0_11_33 VPWR VGND VPWR VGND sky130_fd_sc_hd__decap_3
XPHY_EDGE_ROW_23_Left_57 VPWR VGND VPWR VGND sky130_fd_sc_hd__decap_3
XFILLER_0_11_66 VPWR VGND VPWR VGND sky130_fd_sc_hd__decap_3
XFILLER_0_11_99 VPWR VGND VPWR VGND sky130_fd_sc_hd__decap_3
XFILLER_0_11_305 VPWR VGND VPWR VGND sky130_fd_sc_hd__decap_3
X_288_ VGND VPWR VGND VPWR vn.count[2] vn.count[3] _108_ vn.count[1] vn.count[0] sky130_fd_sc_hd__nand4_2
XFILLER_0_14_110 VPWR VGND VPWR VGND sky130_fd_sc_hd__decap_3
Xadd2.bit_add\[12\].fa.fa VPWR VGND VGND VPWR add1.bit_add\[12\].fa.a add2.bit_add\[12\].fa.co
+ add2.bit_add\[12\].fa.a add2.bit_add\[11\].fa.co add2.bit_add\[12\].fa.sum sky130_fd_sc_hd__fa_1
X_211_ VGND VPWR _088_ _089_ _087_ VPWR VGND sky130_fd_sc_hd__xnor2_1
X_142_ VPWR VGND VGND VPWR _032_ _035_ phase[4] phase[5] _034_ sky130_fd_sc_hd__o211ai_1
XANTENNA__403__D tap_n[3] VGND VPWR VPWR VGND sky130_fd_sc_hd__diode_2
X_409_ meta[9] clknet_4_10_0_clk tap_n[9] VPWR VGND VPWR VGND sky130_fd_sc_hd__dfxtp_1
XFILLER_0_7_129 VPWR VGND VPWR VGND sky130_fd_sc_hd__decap_3
XFILLER_0_22_32 VPWR VGND VPWR VGND sky130_fd_sc_hd__decap_3
XFILLER_0_11_102 VPWR VGND VPWR VGND sky130_fd_sc_hd__decap_3
XFILLER_0_11_113 VPWR VGND VPWR VGND sky130_fd_sc_hd__decap_3
XFILLER_0_2_42 VPWR VGND VPWR VGND sky130_fd_sc_hd__decap_3
X_125_ VPWR VGND VGND VPWR clear_sync[1] _018_ _004_ sky130_fd_sc_hd__nor2_1
XFILLER_0_33_293 VPWR VGND VPWR VGND sky130_fd_sc_hd__decap_3
XFILLER_0_33_271 VPWR VGND VPWR VGND sky130_fd_sc_hd__decap_3
XPHY_EDGE_ROW_26_Left_60 VPWR VGND VPWR VGND sky130_fd_sc_hd__decap_3
XFILLER_0_3_187 VPWR VGND VPWR VGND sky130_fd_sc_hd__decap_3
XFILLER_0_3_165 VPWR VGND VPWR VGND sky130_fd_sc_hd__decap_3
XFILLER_0_16_249 VPWR VGND VPWR VGND sky130_fd_sc_hd__decap_3
XPHY_EDGE_ROW_10_Left_44 VPWR VGND VPWR VGND sky130_fd_sc_hd__decap_3
XFILLER_0_30_296 VPWR VGND VPWR VGND sky130_fd_sc_hd__decap_3
XFILLER_0_28_53 VPWR VGND VPWR VGND sky130_fd_sc_hd__decap_3
XFILLER_0_0_113 VPWR VGND VPWR VGND sky130_fd_sc_hd__decap_3
XFILLER_0_0_179 VPWR VGND VPWR VGND sky130_fd_sc_hd__decap_3
XFILLER_0_8_41 VPWR VGND VPWR VGND sky130_fd_sc_hd__decap_3
XFILLER_0_8_74 VPWR VGND VPWR VGND sky130_fd_sc_hd__decap_3
X_390_ VGND VPWR VPWR VGND clknet_4_7_0_clk add2.bit_add\[17\].fa.sum net3 add2.bit_add\[17\].fa.a
+ sky130_fd_sc_hd__dfrtp_1
XANTENNA__411__D tap_n[11] VGND VPWR VPWR VGND sky130_fd_sc_hd__diode_2
XFILLER_0_14_44 VPWR VGND VPWR VGND sky130_fd_sc_hd__decap_3
Xadd1.bit_add\[4\].fa.fa VPWR VGND VGND VPWR add1.bit_add\[10\].fa.b add1.bit_add\[4\].fa.co
+ add1.bit_add\[4\].fa.a add1.bit_add\[3\].fa.co add1.bit_add\[4\].fa.sum sky130_fd_sc_hd__fa_1
XFILLER_0_32_303 VPWR VGND VPWR VGND sky130_fd_sc_hd__decap_3
XFILLER_0_17_311 VPWR VGND VPWR VGND sky130_fd_sc_hd__decap_3
X_373_ VGND VPWR VPWR VGND clknet_4_13_0_clk add2.bit_add\[0\].fa.sum net3 add2.bit_add\[0\].fa.a
+ sky130_fd_sc_hd__dfrtp_1
X_442_ sync[12] clknet_4_10_0_clk meta[12] VPWR VGND VPWR VGND sky130_fd_sc_hd__dfxtp_1
XANTENNA__406__D tap_n[6] VGND VPWR VPWR VGND sky130_fd_sc_hd__diode_2
XFILLER_0_26_141 VPWR VGND VPWR VGND sky130_fd_sc_hd__decap_3
Xpn.column\[2\].fa.fa VPWR VGND VGND VPWR pn.column\[2\].fa.b pn.column\[2\].fa.co
+ pn.column\[2\].fa.a pn.column\[2\].fa.ci pn.column\[2\].fa.sum sky130_fd_sc_hd__fa_1
Xclkbuf_1_0__f_vn.cg.gclk VGND VPWR clknet_0_vn.cg.gclk clknet_1_0__leaf_vn.cg.gclk
+ VPWR VGND sky130_fd_sc_hd__clkbuf_4
X_356_ VGND VPWR VPWR VGND clknet_4_12_0_clk add1.bit_add\[4\].fa.sum cic_n add1.bit_add\[4\].fa.a
+ sky130_fd_sc_hd__dfrtp_1
X_425_ meta[25] clknet_4_3_0_clk tap_p[10] VPWR VGND VPWR VGND sky130_fd_sc_hd__dfxtp_1
XFILLER_0_11_12 VPWR VGND VPWR VGND sky130_fd_sc_hd__decap_3
XFILLER_0_11_45 VPWR VGND VPWR VGND sky130_fd_sc_hd__decap_3
X_287_ VGND VPWR _107_ _112_[2] vn.count[2] VPWR VGND sky130_fd_sc_hd__xnor2_1
XFILLER_0_11_78 VPWR VGND VPWR VGND sky130_fd_sc_hd__decap_3
XFILLER_0_14_122 VPWR VGND VPWR VGND sky130_fd_sc_hd__decap_3
XFILLER_0_14_144 VPWR VGND VPWR VGND sky130_fd_sc_hd__decap_3
XFILLER_0_14_188 VPWR VGND VPWR VGND sky130_fd_sc_hd__decap_3
X_210_ VGND VPWR pn.f5.sum _088_ pp.f5.sum VPWR VGND sky130_fd_sc_hd__xnor2_1
X_141_ VPWR VGND VGND VPWR _020_ _028_ _033_ _021_ _034_ sky130_fd_sc_hd__o22ai_1
X_408_ meta[8] clknet_4_10_0_clk tap_n[8] VPWR VGND VPWR VGND sky130_fd_sc_hd__dfxtp_1
Xadd1.bit_add\[19\].fa.fa VPWR VGND VGND VPWR add1.bit_add\[10\].fa.b add1.bit_add\[19\].fa.co
+ add1.bit_add\[19\].fa.a add1.bit_add\[18\].fa.co add1.bit_add\[19\].fa.sum sky130_fd_sc_hd__fa_1
X_339_ delay2[19] clknet_2_2__leaf_g_delay.gclk delay2[20] VPWR VGND VPWR VGND sky130_fd_sc_hd__dfxtp_1
XFILLER_0_3_314 VPWR VGND VPWR VGND sky130_fd_sc_hd__decap_3
XFILLER_0_11_125 VPWR VGND VPWR VGND sky130_fd_sc_hd__decap_3
XFILLER_0_11_147 VPWR VGND VPWR VGND sky130_fd_sc_hd__decap_3
XFILLER_0_11_169 VPWR VGND VPWR VGND sky130_fd_sc_hd__decap_3
XFILLER_0_2_32 VPWR VGND VPWR VGND sky130_fd_sc_hd__decap_3
XFILLER_0_2_21 VPWR VGND VPWR VGND sky130_fd_sc_hd__decap_3
XFILLER_0_10_180 VPWR VGND VPWR VGND sky130_fd_sc_hd__decap_3
Xadd1.bit_add\[20\].fa.fa VPWR VGND VGND VPWR add1.bit_add\[10\].fa.b add1.bit_add\[20\].fa.fa/COUT
+ add1.bit_add\[20\].fa.a add1.bit_add\[19\].fa.co add1.bit_add\[20\].fa.sum sky130_fd_sc_hd__fa_1
X_124_ VPWR VGND VPWR VGND _017_ valid[3] wrap_err _018_ sky130_fd_sc_hd__a21oi_1
XFILLER_0_25_206 VPWR VGND VPWR VGND sky130_fd_sc_hd__decap_3
XANTENNA__414__D tap_n[14] VGND VPWR VPWR VGND sky130_fd_sc_hd__diode_2
Xclkbuf_4_9_0_clk VGND VPWR clknet_0_clk clknet_4_9_0_clk VPWR VGND sky130_fd_sc_hd__clkbuf_4
Xclkbuf_0_vp.cg.gclk VGND VPWR vp.cg.gclk clknet_0_vp.cg.gclk VPWR VGND sky130_fd_sc_hd__clkbuf_4
XFILLER_0_33_32 VPWR VGND VPWR VGND sky130_fd_sc_hd__decap_3
XFILLER_0_33_21 VPWR VGND VPWR VGND sky130_fd_sc_hd__decap_3
XANTENNA__409__D tap_n[9] VGND VPWR VPWR VGND sky130_fd_sc_hd__diode_2
XFILLER_0_21_275 VPWR VGND VPWR VGND sky130_fd_sc_hd__decap_3
Xadd1.bit_add\[0\].fa.fa VPWR VGND VGND VPWR add1.bit_add\[0\].fa.b add1.bit_add\[0\].fa.co
+ add1.bit_add\[0\].fa.a net4 add1.bit_add\[0\].fa.sum sky130_fd_sc_hd__fa_1
XFILLER_0_8_53 VPWR VGND VPWR VGND sky130_fd_sc_hd__decap_3
XFILLER_0_12_253 VPWR VGND VPWR VGND sky130_fd_sc_hd__decap_3
XFILLER_0_12_286 VPWR VGND VPWR VGND sky130_fd_sc_hd__decap_3
Xpp.column\[1\].fa.fa VPWR VGND VGND VPWR pp.column\[1\].fa.b pp.column\[1\].fa.co
+ pp.column\[1\].fa.a pp.column\[1\].fa.ci pp.column\[1\].fa.sum sky130_fd_sc_hd__fa_1
XFILLER_0_7_291 VPWR VGND VPWR VGND sky130_fd_sc_hd__decap_3
XFILLER_0_26_312 VPWR VGND VPWR VGND sky130_fd_sc_hd__decap_3
XFILLER_0_30_88 VPWR VGND VPWR VGND sky130_fd_sc_hd__decap_3
XANTENNA__200__SLEEP dbg_mode[0] VGND VPWR VPWR VGND sky130_fd_sc_hd__diode_2
XFILLER_0_29_194 VPWR VGND VPWR VGND sky130_fd_sc_hd__decap_3
X_441_ sync[11] clknet_4_10_0_clk meta[11] VPWR VGND VPWR VGND sky130_fd_sc_hd__dfxtp_1
X_372_ VGND VPWR VPWR VGND clknet_4_7_0_clk add1.bit_add\[20\].fa.sum net3 add1.bit_add\[20\].fa.a
+ sky130_fd_sc_hd__dfrtp_1
XANTENNA__422__D tap_p[7] VGND VPWR VPWR VGND sky130_fd_sc_hd__diode_2
XFILLER_0_5_21 VPWR VGND VPWR VGND sky130_fd_sc_hd__decap_3
Xbit_store\[11\].ff VPWR VGND work[11] clknet_1_1__leaf_g_work.gclk work[12] capture
+ net20 VPWR VGND sky130_fd_sc_hd__sdfxtp_1
XANTENNA__417__D tap_p[2] VGND VPWR VPWR VGND sky130_fd_sc_hd__diode_2
X_424_ meta[24] clknet_4_1_0_clk tap_p[9] VPWR VGND VPWR VGND sky130_fd_sc_hd__dfxtp_1
X_355_ VGND VPWR VPWR VGND clknet_4_13_0_clk add1.bit_add\[3\].fa.sum net3 add1.bit_add\[3\].fa.a
+ sky130_fd_sc_hd__dfrtp_1
XFILLER_0_11_57 VPWR VGND VPWR VGND sky130_fd_sc_hd__decap_3
X_286_ VGND VPWR VPWR VGND vn.count[0] _112_[1] vn.count[1] sky130_fd_sc_hd__xor2_1
Xadd1.bit_add\[15\].fa.fa VPWR VGND VGND VPWR add1.bit_add\[10\].fa.b add1.bit_add\[15\].fa.co
+ add1.bit_add\[15\].fa.a add1.bit_add\[14\].fa.co add1.bit_add\[15\].fa.sum sky130_fd_sc_hd__fa_1
XFILLER_0_14_134 VPWR VGND VPWR VGND sky130_fd_sc_hd__decap_3
XFILLER_0_9_161 VPWR VGND VPWR VGND sky130_fd_sc_hd__decap_3
XPHY_EDGE_ROW_14_Right_14 VPWR VGND VPWR VGND sky130_fd_sc_hd__decap_3
X_140_ VGND VPWR VPWR VGND phase[2] work[12] work[11] _033_ sky130_fd_sc_hd__mux2i_2
XPHY_EDGE_ROW_23_Right_23 VPWR VGND VPWR VGND sky130_fd_sc_hd__decap_3
XPHY_EDGE_ROW_32_Right_32 VPWR VGND VPWR VGND sky130_fd_sc_hd__decap_3
X_338_ delay2[18] clknet_2_3__leaf_g_delay.gclk delay2[19] VPWR VGND VPWR VGND sky130_fd_sc_hd__dfxtp_1
X_407_ meta[7] clknet_4_10_0_clk tap_n[7] VPWR VGND VPWR VGND sky130_fd_sc_hd__dfxtp_1
X_269_ VGND VPWR VPWR VGND sync[15] pp.column\[0\].fa.a prev[15] sky130_fd_sc_hd__xor2_1
XANTENNA__501__RESET_B rst_n VGND VPWR VPWR VGND sky130_fd_sc_hd__diode_2
XFILLER_0_11_159 VPWR VGND VPWR VGND sky130_fd_sc_hd__decap_3
XFILLER_0_2_77 VPWR VGND VPWR VGND sky130_fd_sc_hd__decap_3
XFILLER_0_10_192 VPWR VGND VPWR VGND sky130_fd_sc_hd__decap_3
XFILLER_0_33_284 VPWR VGND VPWR VGND sky130_fd_sc_hd__decap_3
XFILLER_0_33_262 VPWR VGND VPWR VGND sky130_fd_sc_hd__decap_3
X_123_ VPWR VGND VGND VPWR _015_ _017_ _016_ sky130_fd_sc_hd__nand2_1
XFILLER_0_17_67 VPWR VGND VPWR VGND sky130_fd_sc_hd__decap_3
XFILLER_0_3_178 VPWR VGND VPWR VGND sky130_fd_sc_hd__decap_3
XFILLER_0_3_156 VPWR VGND VPWR VGND sky130_fd_sc_hd__decap_3
XFILLER_0_28_3 VPWR VGND VPWR VGND sky130_fd_sc_hd__decap_3
XANTENNA__494__RESET_B rst_n VGND VPWR VPWR VGND sky130_fd_sc_hd__diode_2
XFILLER_0_30_287 VPWR VGND VPWR VGND sky130_fd_sc_hd__decap_3
XANTENNA__425__D tap_p[10] VGND VPWR VPWR VGND sky130_fd_sc_hd__diode_2
XFILLER_0_0_104 VPWR VGND VPWR VGND sky130_fd_sc_hd__decap_3
XFILLER_0_0_137 VPWR VGND VPWR VGND sky130_fd_sc_hd__decap_3
XFILLER_0_28_77 VPWR VGND VPWR VGND sky130_fd_sc_hd__decap_3
XFILLER_0_29_310 VPWR VGND VPWR VGND sky130_fd_sc_hd__decap_3
XFILLER_0_14_9 VPWR VGND VPWR VGND sky130_fd_sc_hd__decap_3
XFILLER_0_8_21 VPWR VGND VPWR VGND sky130_fd_sc_hd__decap_3
XFILLER_0_8_32 VPWR VGND VPWR VGND sky130_fd_sc_hd__decap_3
XFILLER_0_8_65 VPWR VGND VPWR VGND sky130_fd_sc_hd__decap_3
XFILLER_0_8_248 VPWR VGND VPWR VGND sky130_fd_sc_hd__decap_3
XFILLER_0_8_259 VPWR VGND VPWR VGND sky130_fd_sc_hd__decap_3
XPHY_EDGE_ROW_4_Right_4 VPWR VGND VPWR VGND sky130_fd_sc_hd__decap_3
XFILLER_0_8_98 VPWR VGND VPWR VGND sky130_fd_sc_hd__decap_3
XFILLER_0_12_265 VPWR VGND VPWR VGND sky130_fd_sc_hd__decap_3
XFILLER_0_12_298 VPWR VGND VPWR VGND sky130_fd_sc_hd__decap_3
Xclkbuf_4_8_0_clk VGND VPWR clknet_0_clk clknet_4_8_0_clk VPWR VGND sky130_fd_sc_hd__clkbuf_4
Xclkbuf_2_3__f_g_delay.gclk VGND VPWR clknet_0_g_delay.gclk clknet_2_3__leaf_g_delay.gclk
+ VPWR VGND sky130_fd_sc_hd__clkbuf_4
XFILLER_0_14_35 VPWR VGND VPWR VGND sky130_fd_sc_hd__decap_3
XFILLER_0_30_78 VPWR VGND VPWR VGND sky130_fd_sc_hd__decap_3
XFILLER_0_26_302 VPWR VGND VPWR VGND sky130_fd_sc_hd__decap_3
XFILLER_0_12_6 VPWR VGND VPWR VGND sky130_fd_sc_hd__decap_3
XFILLER_0_3_9 VPWR VGND VPWR VGND sky130_fd_sc_hd__decap_3
X_440_ sync[10] clknet_4_10_0_clk meta[10] VPWR VGND VPWR VGND sky130_fd_sc_hd__dfxtp_1
X_371_ VGND VPWR VPWR VGND clknet_4_4_0_clk add1.bit_add\[19\].fa.sum net3 add1.bit_add\[19\].fa.a
+ sky130_fd_sc_hd__dfrtp_1
Xadd1.bit_add\[11\].fa.fa VPWR VGND VGND VPWR net1 add1.bit_add\[11\].fa.co add1.bit_add\[11\].fa.a
+ add1.bit_add\[10\].fa.co add1.bit_add\[11\].fa.sum sky130_fd_sc_hd__fa_1
XFILLER_0_26_132 VPWR VGND VPWR VGND sky130_fd_sc_hd__decap_3
XFILLER_0_14_305 VPWR VGND VPWR VGND sky130_fd_sc_hd__decap_3
XFILLER_0_10_3 VPWR VGND VPWR VGND sky130_fd_sc_hd__decap_3
X_354_ VGND VPWR VPWR VGND clknet_4_5_0_clk add1.bit_add\[2\].fa.sum net3 add1.bit_add\[2\].fa.a
+ sky130_fd_sc_hd__dfrtp_1
X_423_ meta[23] clknet_4_1_0_clk tap_p[8] VPWR VGND VPWR VGND sky130_fd_sc_hd__dfxtp_1
XFILLER_0_23_113 VPWR VGND VPWR VGND sky130_fd_sc_hd__decap_3
XFILLER_0_11_36 VPWR VGND VPWR VGND sky130_fd_sc_hd__decap_3
XFILLER_0_11_69 VPWR VGND VPWR VGND sky130_fd_sc_hd__decap_3
XFILLER_0_11_308 VPWR VGND VPWR VGND sky130_fd_sc_hd__decap_3
X_285_ VPWR VGND VGND VPWR vn.count[0] _107_ vn.count[1] sky130_fd_sc_hd__nand2_1
XFILLER_0_31_190 VPWR VGND VPWR VGND sky130_fd_sc_hd__decap_3
XFILLER_0_14_113 VPWR VGND VPWR VGND sky130_fd_sc_hd__decap_3
XANTENNA__428__D tap_p[13] VGND VPWR VPWR VGND sky130_fd_sc_hd__diode_2
X_337_ delay2[17] clknet_2_2__leaf_g_delay.gclk delay2[18] VPWR VGND VPWR VGND sky130_fd_sc_hd__dfxtp_1
X_406_ meta[6] clknet_4_8_0_clk tap_n[6] VPWR VGND VPWR VGND sky130_fd_sc_hd__dfxtp_1
X_199_ VPWR VGND VGND VPWR _075_ _080_ _010_ sky130_fd_sc_hd__nor2_1
X_268_ VGND VPWR VPWR VGND sync[14] pn.column\[4\].fa.ci prev[14] sky130_fd_sc_hd__xor2_1
XFILLER_0_11_105 VPWR VGND VPWR VGND sky130_fd_sc_hd__decap_3
XFILLER_0_11_116 VPWR VGND VPWR VGND sky130_fd_sc_hd__decap_3
XFILLER_0_11_138 VPWR VGND VPWR VGND sky130_fd_sc_hd__decap_3
XFILLER_0_2_12 VPWR VGND VPWR VGND sky130_fd_sc_hd__decap_3
XFILLER_0_10_171 VPWR VGND VPWR VGND sky130_fd_sc_hd__decap_3
XFILLER_0_33_296 VPWR VGND VPWR VGND sky130_fd_sc_hd__decap_3
XFILLER_0_33_274 VPWR VGND VPWR VGND sky130_fd_sc_hd__decap_3
X_122_ VPWR VGND VGND VPWR pn.f5.sum pn.f5.co _016_ pn.f4.sum sky130_fd_sc_hd__nand3_1
XFILLER_0_18_282 VPWR VGND VPWR VGND sky130_fd_sc_hd__decap_3
XFILLER_0_33_12 VPWR VGND VPWR VGND sky130_fd_sc_hd__decap_3
XFILLER_0_17_57 VPWR VGND VPWR VGND sky130_fd_sc_hd__decap_3
XFILLER_0_30_200 VPWR VGND VPWR VGND sky130_fd_sc_hd__decap_3
XFILLER_0_30_299 VPWR VGND VPWR VGND sky130_fd_sc_hd__decap_3
XFILLER_0_0_116 VPWR VGND VPWR VGND sky130_fd_sc_hd__decap_3
XANTENNA_clkbuf_0_tap_p[0]_A tap_p[0] VGND VPWR VPWR VGND sky130_fd_sc_hd__diode_2
XPHY_EDGE_ROW_14_Left_48 VPWR VGND VPWR VGND sky130_fd_sc_hd__decap_3
XFILLER_0_8_44 VPWR VGND VPWR VGND sky130_fd_sc_hd__decap_3
XFILLER_0_12_200 VPWR VGND VPWR VGND sky130_fd_sc_hd__decap_3
XFILLER_0_14_47 VPWR VGND VPWR VGND sky130_fd_sc_hd__decap_3
Xclkbuf_0_tap_n[0] VGND VPWR tap_n[0] clknet_0_tap_n[0] VPWR VGND sky130_fd_sc_hd__clkbuf_4
XFILLER_0_29_185 VPWR VGND VPWR VGND sky130_fd_sc_hd__decap_3
XFILLER_0_17_314 VPWR VGND VPWR VGND sky130_fd_sc_hd__decap_3
XFILLER_0_4_241 VPWR VGND VPWR VGND sky130_fd_sc_hd__decap_3
X_370_ VGND VPWR VPWR VGND clknet_4_6_0_clk add1.bit_add\[18\].fa.sum net3 add1.bit_add\[18\].fa.a
+ sky130_fd_sc_hd__dfrtp_1
Xg_work.cg VGND VPWR g_work.gclk g_work.en clknet_4_5_0_clk VPWR VGND sky130_fd_sc_hd__dlclkp_1
X_499_ VGND VPWR VPWR VGND clknet_1_1__leaf_vp.cg.gclk _114_[3] rst_n vp.count[3]
+ sky130_fd_sc_hd__dfrtp_1
XFILLER_0_5_12 VPWR VGND VPWR VGND sky130_fd_sc_hd__decap_3
Xclkbuf_4_7_0_clk VGND VPWR clknet_0_clk clknet_4_7_0_clk VPWR VGND sky130_fd_sc_hd__clkbuf_4
XPHY_EDGE_ROW_17_Left_51 VPWR VGND VPWR VGND sky130_fd_sc_hd__decap_3
Xadd2.bit_add\[7\].fa.fa VPWR VGND VGND VPWR add1.bit_add\[7\].fa.a add2.bit_add\[7\].fa.co
+ add2.bit_add\[7\].fa.a add2.bit_add\[6\].fa.co add2.bit_add\[7\].fa.sum sky130_fd_sc_hd__fa_1
XFILLER_0_20_309 VPWR VGND VPWR VGND sky130_fd_sc_hd__decap_3
X_353_ VGND VPWR VPWR VGND clknet_4_7_0_clk add1.bit_add\[1\].fa.sum net3 add1.bit_add\[1\].fa.a
+ sky130_fd_sc_hd__dfrtp_1
X_284_ VGND VPWR _071_ second net29 VPWR VGND sky130_fd_sc_hd__xnor2_1
X_422_ meta[22] clknet_4_0_0_clk tap_p[7] VPWR VGND VPWR VGND sky130_fd_sc_hd__dfxtp_1
XFILLER_0_11_15 VPWR VGND VPWR VGND sky130_fd_sc_hd__decap_3
XFILLER_0_23_169 VPWR VGND VPWR VGND sky130_fd_sc_hd__decap_3
XFILLER_0_11_48 VPWR VGND VPWR VGND sky130_fd_sc_hd__decap_3
Xvp.cg.cg VGND VPWR vp.cg.gclk vn.cg.en clknet_1_1__leaf_tap_p[0] VPWR VGND sky130_fd_sc_hd__dlclkp_1
XFILLER_0_14_125 VPWR VGND VPWR VGND sky130_fd_sc_hd__decap_3
XPHY_EDGE_ROW_2_Left_36 VPWR VGND VPWR VGND sky130_fd_sc_hd__decap_3
X_336_ delay2[16] clknet_2_2__leaf_g_delay.gclk delay2[17] VPWR VGND VPWR VGND sky130_fd_sc_hd__dfxtp_1
X_405_ meta[5] clknet_4_8_0_clk tap_n[5] VPWR VGND VPWR VGND sky130_fd_sc_hd__dfxtp_1
X_267_ VGND VPWR VPWR VGND sync[13] pn.column\[4\].fa.b prev[13] sky130_fd_sc_hd__xor2_1
X_198_ VPWR VGND VGND VPWR sampled _079_ _080_ sky130_fd_sc_hd__nor2_1
XFILLER_0_2_35 VPWR VGND VPWR VGND sky130_fd_sc_hd__decap_3
XFILLER_0_2_24 VPWR VGND VPWR VGND sky130_fd_sc_hd__decap_3
XFILLER_0_12_80 VPWR VGND VPWR VGND sky130_fd_sc_hd__decap_3
XFILLER_0_12_91 VPWR VGND VPWR VGND sky130_fd_sc_hd__decap_3
XFILLER_0_10_150 VPWR VGND VPWR VGND sky130_fd_sc_hd__decap_3
XFILLER_0_10_183 VPWR VGND VPWR VGND sky130_fd_sc_hd__decap_3
X_121_ VPWR VGND VGND VPWR pp.f5.sum pp.f5.co _015_ pp.f4.sum sky130_fd_sc_hd__nand3_1
XFILLER_0_25_209 VPWR VGND VPWR VGND sky130_fd_sc_hd__decap_3
XFILLER_0_33_231 VPWR VGND VPWR VGND sky130_fd_sc_hd__decap_3
XFILLER_0_0_309 VPWR VGND VPWR VGND sky130_fd_sc_hd__decap_3
XFILLER_0_33_57 VPWR VGND VPWR VGND sky130_fd_sc_hd__decap_3
XFILLER_0_33_35 VPWR VGND VPWR VGND sky130_fd_sc_hd__decap_3
XFILLER_0_33_24 VPWR VGND VPWR VGND sky130_fd_sc_hd__decap_3
X_319_ delay1[20] clknet_2_3__leaf_g_delay.gclk a VPWR VGND VPWR VGND sky130_fd_sc_hd__dfxtp_1
XFILLER_0_3_169 VPWR VGND VPWR VGND sky130_fd_sc_hd__decap_3
XFILLER_0_3_147 VPWR VGND VPWR VGND sky130_fd_sc_hd__decap_3
XFILLER_0_30_278 VPWR VGND VPWR VGND sky130_fd_sc_hd__decap_3
XFILLER_0_15_231 VPWR VGND VPWR VGND sky130_fd_sc_hd__decap_3
XFILLER_0_29_301 VPWR VGND VPWR VGND sky130_fd_sc_hd__decap_3
XFILLER_0_8_12 VPWR VGND VPWR VGND sky130_fd_sc_hd__decap_3
XFILLER_0_8_56 VPWR VGND VPWR VGND sky130_fd_sc_hd__decap_3
XFILLER_0_12_256 VPWR VGND VPWR VGND sky130_fd_sc_hd__decap_3
XFILLER_0_33_3 VPWR VGND VPWR VGND sky130_fd_sc_hd__decap_3
XFILLER_0_12_289 VPWR VGND VPWR VGND sky130_fd_sc_hd__decap_3
XPHY_EDGE_ROW_31_Left_65 VPWR VGND VPWR VGND sky130_fd_sc_hd__decap_3
Xbit_store\[14\].ff VPWR VGND work[14] clknet_1_1__leaf_g_work.gclk work[15] capture
+ net10 VPWR VGND sky130_fd_sc_hd__sdfxtp_1
XFILLER_0_30_69 VPWR VGND VPWR VGND sky130_fd_sc_hd__decap_3
XFILLER_0_29_197 VPWR VGND VPWR VGND sky130_fd_sc_hd__decap_3
XFILLER_0_20_91 VPWR VGND VPWR VGND sky130_fd_sc_hd__decap_3
Xadd2.bit_add\[3\].fa.fa VPWR VGND VGND VPWR add1.bit_add\[3\].fa.a add2.bit_add\[3\].fa.co
+ add2.bit_add\[3\].fa.a add2.bit_add\[2\].fa.co add2.bit_add\[3\].fa.sum sky130_fd_sc_hd__fa_1
XFILLER_0_26_167 VPWR VGND VPWR VGND sky130_fd_sc_hd__decap_3
X_498_ VGND VPWR VPWR VGND clknet_1_0__leaf_vp.cg.gclk _114_[2] rst_n vp.count[2]
+ sky130_fd_sc_hd__dfrtp_1
XFILLER_0_5_24 VPWR VGND VPWR VGND sky130_fd_sc_hd__decap_3
Xbit_store\[1\].ff VPWR VGND shift_word[0] clknet_1_0__leaf_g_work.gclk shift_word[1]
+ capture net12 VPWR VGND sky130_fd_sc_hd__sdfxtp_1
X_421_ meta[21] clknet_4_1_0_clk tap_p[6] VPWR VGND VPWR VGND sky130_fd_sc_hd__dfxtp_1
X_352_ VGND VPWR VPWR VGND clknet_4_7_0_clk add1.bit_add\[0\].fa.sum net3 add1.bit_add\[0\].fa.a
+ sky130_fd_sc_hd__dfrtp_1
X_283_ VGND VPWR VPWR VGND sync[29] pp.column\[4\].fa.ci prev[29] sky130_fd_sc_hd__xor2_1
XFILLER_0_11_27 VPWR VGND VPWR VGND sky130_fd_sc_hd__decap_3
XFILLER_0_14_104 VPWR VGND VPWR VGND sky130_fd_sc_hd__decap_3
XFILLER_0_14_137 VPWR VGND VPWR VGND sky130_fd_sc_hd__decap_3
XFILLER_0_22_181 VPWR VGND VPWR VGND sky130_fd_sc_hd__decap_3
XFILLER_0_9_131 VPWR VGND VPWR VGND sky130_fd_sc_hd__decap_3
XFILLER_0_9_164 VPWR VGND VPWR VGND sky130_fd_sc_hd__decap_3
X_404_ meta[4] clknet_4_8_0_clk tap_n[4] VPWR VGND VPWR VGND sky130_fd_sc_hd__dfxtp_1
X_197_ VPWR VGND VPWR VGND _078_ _079_ rate _014_ sky130_fd_sc_hd__a21boi_1
X_335_ delay2[15] clknet_2_0__leaf_g_delay.gclk delay2[16] VPWR VGND VPWR VGND sky130_fd_sc_hd__dfxtp_1
X_266_ VGND VPWR VPWR VGND sync[12] pn.column\[4\].fa.a prev[12] sky130_fd_sc_hd__xor2_1
Xclkbuf_4_6_0_clk VGND VPWR clknet_0_clk clknet_4_6_0_clk VPWR VGND sky130_fd_sc_hd__clkbuf_4
XPHY_EDGE_ROW_10_Right_10 VPWR VGND VPWR VGND sky130_fd_sc_hd__decap_3
Xclkbuf_0_g_work.gclk VGND VPWR g_work.gclk clknet_0_g_work.gclk VPWR VGND sky130_fd_sc_hd__clkbuf_4
Xclkbuf_1_1__f_vp.cg.gclk VGND VPWR clknet_0_vp.cg.gclk clknet_1_1__leaf_vp.cg.gclk
+ VPWR VGND sky130_fd_sc_hd__clkbuf_4
XFILLER_0_10_162 VPWR VGND VPWR VGND sky130_fd_sc_hd__decap_3
XFILLER_0_33_221 VPWR VGND VPWR VGND sky130_fd_sc_hd__decap_3
X_120_ VPWR VGND VGND VPWR vp.count[0] _113_[0] sky130_fd_sc_hd__inv_1
XFILLER_0_33_287 VPWR VGND VPWR VGND sky130_fd_sc_hd__decap_3
XFILLER_0_33_265 VPWR VGND VPWR VGND sky130_fd_sc_hd__decap_3
X_318_ delay1[19] clknet_2_1__leaf_g_delay.gclk delay1[20] VPWR VGND VPWR VGND sky130_fd_sc_hd__dfxtp_1
XFILLER_0_24_210 VPWR VGND VPWR VGND sky130_fd_sc_hd__decap_3
XFILLER_0_3_159 VPWR VGND VPWR VGND sky130_fd_sc_hd__decap_3
X_249_ VPWR VGND VGND VPWR _104_ _105_ _114_[3] sky130_fd_sc_hd__lpflow_isobufsrc_1
XFILLER_0_28_6 VPWR VGND VPWR VGND sky130_fd_sc_hd__decap_3
XFILLER_0_2_192 VPWR VGND VPWR VGND sky130_fd_sc_hd__decap_3
XFILLER_0_0_107 VPWR VGND VPWR VGND sky130_fd_sc_hd__decap_3
XFILLER_0_29_313 VPWR VGND VPWR VGND sky130_fd_sc_hd__decap_3
XFILLER_0_8_24 VPWR VGND VPWR VGND sky130_fd_sc_hd__decap_3
XFILLER_0_8_35 VPWR VGND VPWR VGND sky130_fd_sc_hd__decap_3
XFILLER_0_8_68 VPWR VGND VPWR VGND sky130_fd_sc_hd__decap_3
XFILLER_0_12_246 VPWR VGND VPWR VGND sky130_fd_sc_hd__decap_3
XFILLER_0_26_3 VPWR VGND VPWR VGND sky130_fd_sc_hd__decap_3
XFILLER_0_11_290 VPWR VGND VPWR VGND sky130_fd_sc_hd__decap_3
XFILLER_0_26_305 VPWR VGND VPWR VGND sky130_fd_sc_hd__decap_3
XFILLER_0_14_38 VPWR VGND VPWR VGND sky130_fd_sc_hd__decap_3
Xhold1 net8 add2.bit_add\[19\].fa.a VPWR VGND VGND VPWR sky130_fd_sc_hd__dlygate4sd3_1
XPHY_EDGE_ROW_8_Right_8 VPWR VGND VPWR VGND sky130_fd_sc_hd__decap_3
XFILLER_0_12_9 VPWR VGND VPWR VGND sky130_fd_sc_hd__decap_3
XFILLER_0_4_232 VPWR VGND VPWR VGND sky130_fd_sc_hd__decap_3
XFILLER_0_20_70 VPWR VGND VPWR VGND sky130_fd_sc_hd__decap_3
XFILLER_0_26_135 VPWR VGND VPWR VGND sky130_fd_sc_hd__decap_3
X_497_ VGND VPWR VPWR VGND clknet_1_0__leaf_vp.cg.gclk _114_[1] rst_n vp.count[1]
+ sky130_fd_sc_hd__dfrtp_2
XANTENNA__504__RESET_B rst_n VGND VPWR VPWR VGND sky130_fd_sc_hd__diode_2
XFILLER_0_10_6 VPWR VGND VPWR VGND sky130_fd_sc_hd__decap_3
X_351_ VGND VPWR VPWR VGND clknet_4_13_0_clk _002_[7] run_n phase[7] sky130_fd_sc_hd__dfrtp_2
X_420_ meta[20] clknet_4_1_0_clk tap_p[5] VPWR VGND VPWR VGND sky130_fd_sc_hd__dfxtp_1
X_282_ VGND VPWR VPWR VGND sync[28] pp.column\[4\].fa.b prev[28] sky130_fd_sc_hd__xor2_1
XFILLER_0_11_39 VPWR VGND VPWR VGND sky130_fd_sc_hd__decap_3
XFILLER_0_31_193 VPWR VGND VPWR VGND sky130_fd_sc_hd__decap_3
XFILLER_0_14_116 VPWR VGND VPWR VGND sky130_fd_sc_hd__decap_3
XANTENNA__497__RESET_B rst_n VGND VPWR VPWR VGND sky130_fd_sc_hd__diode_2
X_334_ delay2[14] clknet_2_0__leaf_g_delay.gclk delay2[15] VPWR VGND VPWR VGND sky130_fd_sc_hd__dfxtp_1
X_403_ meta[3] clknet_4_8_0_clk tap_n[3] VPWR VGND VPWR VGND sky130_fd_sc_hd__dfxtp_1
X_196_ _078_ phase[4] phase[6] phase[5] _077_ VGND VPWR VPWR VGND sky130_fd_sc_hd__and4_1
XFILLER_0_3_308 VPWR VGND VPWR VGND sky130_fd_sc_hd__decap_3
X_265_ VGND VPWR VPWR VGND sync[11] pn.column\[3\].fa.ci prev[11] sky130_fd_sc_hd__xor2_1
XFILLER_0_11_108 VPWR VGND VPWR VGND sky130_fd_sc_hd__decap_3
XFILLER_0_11_119 VPWR VGND VPWR VGND sky130_fd_sc_hd__decap_3
XFILLER_0_2_15 VPWR VGND VPWR VGND sky130_fd_sc_hd__decap_3
XFILLER_0_12_71 VPWR VGND VPWR VGND sky130_fd_sc_hd__decap_3
XFILLER_0_19_219 VPWR VGND VPWR VGND sky130_fd_sc_hd__decap_3
XFILLER_0_10_130 VPWR VGND VPWR VGND sky130_fd_sc_hd__decap_3
XFILLER_0_10_141 VPWR VGND VPWR VGND sky130_fd_sc_hd__decap_3
XFILLER_0_10_174 VPWR VGND VPWR VGND sky130_fd_sc_hd__decap_3
XFILLER_0_33_277 VPWR VGND VPWR VGND sky130_fd_sc_hd__decap_3
XFILLER_0_33_200 VPWR VGND VPWR VGND sky130_fd_sc_hd__decap_3
XFILLER_0_18_285 VPWR VGND VPWR VGND sky130_fd_sc_hd__decap_3
XFILLER_0_33_299 VPWR VGND VPWR VGND sky130_fd_sc_hd__decap_3
XFILLER_0_33_15 VPWR VGND VPWR VGND sky130_fd_sc_hd__decap_3
X_317_ delay1[18] clknet_2_1__leaf_g_delay.gclk delay1[19] VPWR VGND VPWR VGND sky130_fd_sc_hd__dfxtp_1
X_179_ VPWR VGND _067_ _065_ a VPWR VGND sky130_fd_sc_hd__xor2_2
XFILLER_0_24_277 VPWR VGND VPWR VGND sky130_fd_sc_hd__decap_3
X_248_ VGND VPWR VPWR VGND vp.count[2] vp.count[1] vp.count[0] _105_ vp.count[3] sky130_fd_sc_hd__a31oi_1
XFILLER_0_15_255 VPWR VGND VPWR VGND sky130_fd_sc_hd__decap_3
XFILLER_0_2_182 VPWR VGND VPWR VGND sky130_fd_sc_hd__decap_3
Xclkbuf_4_5_0_clk VGND VPWR clknet_0_clk clknet_4_5_0_clk VPWR VGND sky130_fd_sc_hd__clkbuf_4
XFILLER_0_21_269 VPWR VGND VPWR VGND sky130_fd_sc_hd__decap_3
XFILLER_0_8_47 VPWR VGND VPWR VGND sky130_fd_sc_hd__decap_3
XFILLER_0_12_203 VPWR VGND VPWR VGND sky130_fd_sc_hd__decap_3
XFILLER_0_20_280 VPWR VGND VPWR VGND sky130_fd_sc_hd__decap_3
Xvn.cg.cg VGND VPWR vn.cg.gclk vn.cg.en clknet_1_0__leaf_tap_n[0] VPWR VGND sky130_fd_sc_hd__dlclkp_1
Xhold2 net9 add2.bit_add\[13\].fa.a VPWR VGND VGND VPWR sky130_fd_sc_hd__dlygate4sd3_1
XFILLER_0_29_188 VPWR VGND VPWR VGND sky130_fd_sc_hd__decap_3
XFILLER_0_32_309 VPWR VGND VPWR VGND sky130_fd_sc_hd__decap_3
XFILLER_0_4_200 VPWR VGND VPWR VGND sky130_fd_sc_hd__decap_3
XFILLER_0_8_3 VPWR VGND VPWR VGND sky130_fd_sc_hd__decap_3
X_496_ VGND VPWR VPWR VGND clknet_1_0__leaf_vp.cg.gclk _113_[0] rst_n vp.count[0]
+ sky130_fd_sc_hd__dfrtp_2
XFILLER_0_14_309 VPWR VGND VPWR VGND sky130_fd_sc_hd__decap_3
XFILLER_0_5_15 VPWR VGND VPWR VGND sky130_fd_sc_hd__decap_3
X_350_ VGND VPWR VPWR VGND clknet_4_15_0_clk _002_[6] run_n phase[6] sky130_fd_sc_hd__dfrtp_2
X_281_ VGND VPWR VPWR VGND sync[27] pp.column\[4\].fa.a prev[27] sky130_fd_sc_hd__xor2_1
X_479_ prev[19] clknet_4_1_0_clk sync[19] VPWR VGND VPWR VGND sky130_fd_sc_hd__dfxtp_1
XFILLER_0_10_312 VPWR VGND VPWR VGND sky130_fd_sc_hd__decap_3
XFILLER_0_14_128 VPWR VGND VPWR VGND sky130_fd_sc_hd__decap_3
XFILLER_0_22_150 VPWR VGND VPWR VGND sky130_fd_sc_hd__decap_3
XFILLER_0_9_122 VPWR VGND VPWR VGND sky130_fd_sc_hd__decap_3
Xpp.f0.fa VPWR VGND VGND VPWR pp.column\[1\].fa.sum pp.f0.co pp.column\[0\].fa.sum
+ pp.column\[2\].fa.sum pp.f0.sum sky130_fd_sc_hd__fa_1
X_402_ meta[2] clknet_4_8_0_clk tap_n[2] VPWR VGND VPWR VGND sky130_fd_sc_hd__dfxtp_1
X_264_ VGND VPWR VPWR VGND sync[10] pn.column\[3\].fa.b prev[10] sky130_fd_sc_hd__xor2_1
X_333_ delay2[13] clknet_2_0__leaf_g_delay.gclk delay2[14] VPWR VGND VPWR VGND sky130_fd_sc_hd__dfxtp_1
X_195_ VGND VPWR VGND VPWR _077_ phase[3] phase[2] phase[1] phase[0] sky130_fd_sc_hd__and4_2
XFILLER_0_27_297 VPWR VGND VPWR VGND sky130_fd_sc_hd__decap_3
XFILLER_0_12_50 VPWR VGND VPWR VGND sky130_fd_sc_hd__decap_3
XFILLER_0_12_94 VPWR VGND VPWR VGND sky130_fd_sc_hd__decap_3
XFILLER_0_10_153 VPWR VGND VPWR VGND sky130_fd_sc_hd__decap_3
XFILLER_0_10_186 VPWR VGND VPWR VGND sky130_fd_sc_hd__decap_3
XFILLER_0_33_212 VPWR VGND VPWR VGND sky130_fd_sc_hd__decap_3
Xbit_store\[17\].ff VPWR VGND work[17] clknet_1_0__leaf_g_work.gclk work[18] capture
+ net16 VPWR VGND sky130_fd_sc_hd__sdfxtp_1
X_316_ delay1[17] clknet_2_0__leaf_g_delay.gclk delay1[18] VPWR VGND VPWR VGND sky130_fd_sc_hd__dfxtp_1
X_247_ VGND VPWR VGND VPWR vp.count[3] vp.count[2] _104_ vp.count[1] vp.count[0] sky130_fd_sc_hd__nand4_2
X_178_ VPWR VGND VGND VPWR a _065_ _066_ sky130_fd_sc_hd__nor2_1
XFILLER_0_29_304 VPWR VGND VPWR VGND sky130_fd_sc_hd__decap_3
XFILLER_0_8_15 VPWR VGND VPWR VGND sky130_fd_sc_hd__decap_3
XFILLER_0_8_59 VPWR VGND VPWR VGND sky130_fd_sc_hd__decap_3
XFILLER_0_12_259 VPWR VGND VPWR VGND sky130_fd_sc_hd__decap_3
XFILLER_0_33_6 VPWR VGND VPWR VGND sky130_fd_sc_hd__decap_3
Xbit_store\[4\].ff VPWR VGND work[4] clknet_1_1__leaf_g_work.gclk work[5] capture
+ net11 VPWR VGND sky130_fd_sc_hd__sdfxtp_1
Xadd2.bit_add\[19\].fa.fa VPWR VGND VGND VPWR add1.bit_add\[19\].fa.a add2.bit_add\[19\].fa.co
+ add2.bit_add\[19\].fa.a add2.bit_add\[18\].fa.co add2.bit_add\[19\].fa.sum sky130_fd_sc_hd__fa_1
XFILLER_0_11_270 VPWR VGND VPWR VGND sky130_fd_sc_hd__decap_3
XFILLER_0_11_281 VPWR VGND VPWR VGND sky130_fd_sc_hd__decap_3
XPHY_EDGE_ROW_9_Left_43 VPWR VGND VPWR VGND sky130_fd_sc_hd__decap_3
XFILLER_0_14_29 VPWR VGND VPWR VGND sky130_fd_sc_hd__decap_3
Xhold3 net10 add2.bit_add\[14\].fa.a VPWR VGND VGND VPWR sky130_fd_sc_hd__dlygate4sd3_1
XFILLER_0_20_61 VPWR VGND VPWR VGND sky130_fd_sc_hd__decap_3
XFILLER_0_20_94 VPWR VGND VPWR VGND sky130_fd_sc_hd__decap_3
Xadd2.bit_add\[20\].fa.fa VPWR VGND VGND VPWR add1.bit_add\[20\].fa.a add2.bit_add\[20\].fa.fa/COUT
+ add2.bit_add\[20\].fa.a add2.bit_add\[19\].fa.co add2.bit_add\[20\].fa.sum sky130_fd_sc_hd__fa_1
Xclkbuf_4_4_0_clk VGND VPWR clknet_0_clk clknet_4_4_0_clk VPWR VGND sky130_fd_sc_hd__clkbuf_4
XFILLER_0_31_3 VPWR VGND VPWR VGND sky130_fd_sc_hd__decap_3
Xpp.f3.fa VPWR VGND VGND VPWR pp.column\[4\].fa.co pp.f3.co pp.column\[3\].fa.co pp.f0.co
+ pp.f3.sum sky130_fd_sc_hd__fa_1
X_495_ VGND VPWR VPWR VGND clknet_4_4_0_clk reset_sync[0] rst_n run_n sky130_fd_sc_hd__dfrtp_4
XFILLER_0_5_27 VPWR VGND VPWR VGND sky130_fd_sc_hd__decap_3
XFILLER_0_0_281 VPWR VGND VPWR VGND sky130_fd_sc_hd__decap_3
X_280_ VGND VPWR VPWR VGND sync[26] pp.column\[3\].fa.ci prev[26] sky130_fd_sc_hd__xor2_1
XFILLER_0_16_192 VPWR VGND VPWR VGND sky130_fd_sc_hd__decap_3
XANTENNA__490__D err_clr VGND VPWR VPWR VGND sky130_fd_sc_hd__diode_2
X_478_ prev[18] clknet_4_0_0_clk sync[18] VPWR VGND VPWR VGND sky130_fd_sc_hd__dfxtp_1
XFILLER_0_14_107 VPWR VGND VPWR VGND sky130_fd_sc_hd__decap_3
XFILLER_0_10_302 VPWR VGND VPWR VGND sky130_fd_sc_hd__decap_3
XFILLER_0_22_184 VPWR VGND VPWR VGND sky130_fd_sc_hd__decap_3
XFILLER_0_9_101 VPWR VGND VPWR VGND sky130_fd_sc_hd__decap_3
X_401_ meta[1] clknet_4_8_0_clk tap_n[1] VPWR VGND VPWR VGND sky130_fd_sc_hd__dfxtp_1
X_263_ VGND VPWR VPWR VGND sync[9] pn.column\[3\].fa.a prev[9] sky130_fd_sc_hd__xor2_1
XFILLER_0_22_29 VPWR VGND VPWR VGND sky130_fd_sc_hd__decap_3
X_332_ delay2[12] clknet_2_0__leaf_g_delay.gclk delay2[13] VPWR VGND VPWR VGND sky130_fd_sc_hd__dfxtp_1
X_194_ VGND VPWR VPWR VGND _009_ rate_sync[1] _075_ rate sky130_fd_sc_hd__mux2_1
XPHY_EDGE_ROW_22_Left_56 VPWR VGND VPWR VGND sky130_fd_sc_hd__decap_3
XFILLER_0_12_62 VPWR VGND VPWR VGND sky130_fd_sc_hd__decap_3
XFILLER_0_10_121 VPWR VGND VPWR VGND sky130_fd_sc_hd__decap_3
XFILLER_0_10_165 VPWR VGND VPWR VGND sky130_fd_sc_hd__decap_3
XFILLER_0_33_268 VPWR VGND VPWR VGND sky130_fd_sc_hd__decap_3
X_177_ VPWR VGND VGND VPWR history_valid _065_ delay1[0] sky130_fd_sc_hd__nand2_1
X_315_ delay1[16] clknet_2_1__leaf_g_delay.gclk delay1[17] VPWR VGND VPWR VGND sky130_fd_sc_hd__dfxtp_1
X_246_ VGND VPWR _103_ _114_[2] vp.count[2] VPWR VGND sky130_fd_sc_hd__xnor2_1
XFILLER_0_3_60 VPWR VGND VPWR VGND sky130_fd_sc_hd__decap_3
Xadd2.bit_add\[15\].fa.fa VPWR VGND VGND VPWR add1.bit_add\[15\].fa.a add2.bit_add\[15\].fa.co
+ add2.bit_add\[15\].fa.a add2.bit_add\[14\].fa.co add2.bit_add\[15\].fa.sum sky130_fd_sc_hd__fa_1
X_229_ VPWR VGND VGND VPWR phase[0] _075_ _002_[0] sky130_fd_sc_hd__nor2_1
XFILLER_0_8_38 VPWR VGND VPWR VGND sky130_fd_sc_hd__decap_3
XFILLER_0_12_249 VPWR VGND VPWR VGND sky130_fd_sc_hd__decap_3
XFILLER_0_26_6 VPWR VGND VPWR VGND sky130_fd_sc_hd__decap_3
XFILLER_0_7_221 VPWR VGND VPWR VGND sky130_fd_sc_hd__decap_3
XFILLER_0_7_265 VPWR VGND VPWR VGND sky130_fd_sc_hd__decap_3
XFILLER_0_11_293 VPWR VGND VPWR VGND sky130_fd_sc_hd__decap_3
Xhold4 net11 add2.bit_add\[4\].fa.a VPWR VGND VGND VPWR sky130_fd_sc_hd__dlygate4sd3_1
XFILLER_0_29_113 VPWR VGND VPWR VGND sky130_fd_sc_hd__decap_3
XFILLER_0_17_308 VPWR VGND VPWR VGND sky130_fd_sc_hd__decap_3
XFILLER_0_4_235 VPWR VGND VPWR VGND sky130_fd_sc_hd__decap_3
XFILLER_0_20_73 VPWR VGND VPWR VGND sky130_fd_sc_hd__decap_3
XFILLER_0_24_3 VPWR VGND VPWR VGND sky130_fd_sc_hd__decap_3
XFILLER_0_0_61 VPWR VGND VPWR VGND sky130_fd_sc_hd__decap_3
XFILLER_0_31_311 VPWR VGND VPWR VGND sky130_fd_sc_hd__decap_3
XFILLER_0_28_190 VPWR VGND VPWR VGND sky130_fd_sc_hd__decap_3
XPHY_EDGE_ROW_17_Right_17 VPWR VGND VPWR VGND sky130_fd_sc_hd__decap_3
XPHY_EDGE_ROW_26_Right_26 VPWR VGND VPWR VGND sky130_fd_sc_hd__decap_3
X_494_ VGND VPWR VPWR VGND clknet_4_4_0_clk net7 rst_n reset_sync[0] sky130_fd_sc_hd__dfrtp_1
Xclkbuf_0_g_delay.gclk VGND VPWR g_delay.gclk clknet_0_g_delay.gclk VPWR VGND sky130_fd_sc_hd__clkbuf_4
XFILLER_0_10_9 VPWR VGND VPWR VGND sky130_fd_sc_hd__decap_3
XFILLER_0_15_51 VPWR VGND VPWR VGND sky130_fd_sc_hd__decap_3
XFILLER_0_32_108 VPWR VGND VPWR VGND sky130_fd_sc_hd__decap_3
XFILLER_0_13_311 VPWR VGND VPWR VGND sky130_fd_sc_hd__decap_3
XFILLER_0_23_108 VPWR VGND VPWR VGND sky130_fd_sc_hd__decap_3
Xclkbuf_4_3_0_clk VGND VPWR clknet_0_clk clknet_4_3_0_clk VPWR VGND sky130_fd_sc_hd__clkbuf_4
X_477_ prev[17] clknet_4_0_0_clk sync[17] VPWR VGND VPWR VGND sky130_fd_sc_hd__dfxtp_1
XFILLER_0_14_119 VPWR VGND VPWR VGND sky130_fd_sc_hd__decap_3
Xadd1.bit_add\[7\].fa.fa VPWR VGND VGND VPWR net1 add1.bit_add\[7\].fa.co add1.bit_add\[7\].fa.a
+ add1.bit_add\[6\].fa.co add1.bit_add\[7\].fa.sum sky130_fd_sc_hd__fa_1
XFILLER_0_9_113 VPWR VGND VPWR VGND sky130_fd_sc_hd__decap_3
XFILLER_0_13_163 VPWR VGND VPWR VGND sky130_fd_sc_hd__decap_3
XFILLER_0_13_185 VPWR VGND VPWR VGND sky130_fd_sc_hd__decap_3
X_400_ meta[0] clknet_4_2_0_clk clknet_1_1__leaf_tap_n[0] VPWR VGND VPWR VGND sky130_fd_sc_hd__dfxtp_1
X_331_ delay2[11] clknet_2_0__leaf_g_delay.gclk delay2[12] VPWR VGND VPWR VGND sky130_fd_sc_hd__dfxtp_1
X_193_ VPWR VGND VGND VPWR _076_ _059_ _008_ _000_ history_valid sky130_fd_sc_hd__o2bb2ai_1
X_262_ VGND VPWR VPWR VGND sync[8] pn.column\[2\].fa.ci prev[8] sky130_fd_sc_hd__xor2_1
XFILLER_0_2_29 VPWR VGND VPWR VGND sky130_fd_sc_hd__decap_3
XFILLER_0_2_18 VPWR VGND VPWR VGND sky130_fd_sc_hd__decap_3
XFILLER_0_10_100 VPWR VGND VPWR VGND sky130_fd_sc_hd__decap_3
XFILLER_0_12_41 VPWR VGND VPWR VGND sky130_fd_sc_hd__decap_3
XFILLER_0_12_74 VPWR VGND VPWR VGND sky130_fd_sc_hd__decap_3
XFILLER_0_12_85 VPWR VGND VPWR VGND sky130_fd_sc_hd__decap_3
XFILLER_0_10_133 VPWR VGND VPWR VGND sky130_fd_sc_hd__decap_3
XFILLER_0_10_144 VPWR VGND VPWR VGND sky130_fd_sc_hd__decap_3
XFILLER_0_10_177 VPWR VGND VPWR VGND sky130_fd_sc_hd__decap_3
XFILLER_0_33_203 VPWR VGND VPWR VGND sky130_fd_sc_hd__decap_3
Xadd2.bit_add\[11\].fa.fa VPWR VGND VGND VPWR add1.bit_add\[11\].fa.a add2.bit_add\[11\].fa.co
+ add2.bit_add\[11\].fa.a add2.bit_add\[10\].fa.co add2.bit_add\[11\].fa.sum sky130_fd_sc_hd__fa_1
XFILLER_0_33_29 VPWR VGND VPWR VGND sky130_fd_sc_hd__decap_3
XFILLER_0_33_18 VPWR VGND VPWR VGND sky130_fd_sc_hd__decap_3
X_314_ delay1[15] clknet_2_1__leaf_g_delay.gclk delay1[16] VPWR VGND VPWR VGND sky130_fd_sc_hd__dfxtp_1
X_176_ VPWR VGND VGND VPWR _064_ g_work.en sky130_fd_sc_hd__inv_1
X_245_ VGND VPWR VPWR VGND vp.count[0] _114_[1] vp.count[1] sky130_fd_sc_hd__xor2_1
XFILLER_0_23_73 VPWR VGND VPWR VGND sky130_fd_sc_hd__decap_3
XFILLER_0_15_225 VPWR VGND VPWR VGND sky130_fd_sc_hd__decap_3
XFILLER_0_23_51 VPWR VGND VPWR VGND sky130_fd_sc_hd__decap_3
X_228_ VPWR VGND pp.f5.co debug[7] _094_ VPWR VGND sky130_fd_sc_hd__and2_2
X_159_ VPWR VGND VGND VPWR phase[6] phase[5] _052_ phase[7] sky130_fd_sc_hd__nor3b_1
XFILLER_0_12_206 VPWR VGND VPWR VGND sky130_fd_sc_hd__decap_3
XANTENNA__507__RESET_B rst_n VGND VPWR VPWR VGND sky130_fd_sc_hd__diode_2
XFILLER_0_20_283 VPWR VGND VPWR VGND sky130_fd_sc_hd__decap_3
XFILLER_0_7_288 VPWR VGND VPWR VGND sky130_fd_sc_hd__decap_3
XFILLER_0_11_261 VPWR VGND VPWR VGND sky130_fd_sc_hd__decap_3
XANTENNA__219__A dbg_mode[1] VGND VPWR VPWR VGND sky130_fd_sc_hd__diode_2
XFILLER_0_26_309 VPWR VGND VPWR VGND sky130_fd_sc_hd__decap_3
Xpn.f0.fa VPWR VGND VGND VPWR pn.column\[1\].fa.sum pn.f0.co pn.column\[0\].fa.sum
+ pn.column\[2\].fa.sum pn.f0.sum sky130_fd_sc_hd__fa_1
Xhold5 net12 add2.bit_add\[1\].fa.a VPWR VGND VGND VPWR sky130_fd_sc_hd__dlygate4sd3_1
XFILLER_0_4_203 VPWR VGND VPWR VGND sky130_fd_sc_hd__decap_3
XFILLER_0_20_52 VPWR VGND VPWR VGND sky130_fd_sc_hd__decap_3
XFILLER_0_20_85 VPWR VGND VPWR VGND sky130_fd_sc_hd__decap_3
XFILLER_0_17_3 VPWR VGND VPWR VGND sky130_fd_sc_hd__decap_3
XFILLER_0_9_60 VPWR VGND VPWR VGND sky130_fd_sc_hd__decap_3
XFILLER_0_8_6 VPWR VGND VPWR VGND sky130_fd_sc_hd__decap_3
X_493_ VGND VPWR VPWR VGND clknet_4_13_0_clk rate_sync[0] run_n rate_sync[1] sky130_fd_sc_hd__dfrtp_1
XFILLER_0_5_18 VPWR VGND VPWR VGND sky130_fd_sc_hd__decap_3
XFILLER_0_22_312 VPWR VGND VPWR VGND sky130_fd_sc_hd__decap_3
Xadd1.bit_add\[3\].fa.fa VPWR VGND VGND VPWR add1.bit_add\[3\].fa.b add1.bit_add\[3\].fa.co
+ add1.bit_add\[3\].fa.a add1.bit_add\[2\].fa.co add1.bit_add\[3\].fa.sum sky130_fd_sc_hd__fa_1
XFILLER_0_25_172 VPWR VGND VPWR VGND sky130_fd_sc_hd__decap_3
Xpp.column\[4\].fa.fa VPWR VGND VGND VPWR pp.column\[4\].fa.b pp.column\[4\].fa.co
+ pp.column\[4\].fa.a pp.column\[4\].fa.ci pp.column\[4\].fa.sum sky130_fd_sc_hd__fa_1
XFILLER_0_16_150 VPWR VGND VPWR VGND sky130_fd_sc_hd__decap_3
XFILLER_0_6_3 VPWR VGND VPWR VGND sky130_fd_sc_hd__decap_3
X_476_ prev[16] clknet_4_1_0_clk sync[16] VPWR VGND VPWR VGND sky130_fd_sc_hd__dfxtp_1
XFILLER_0_22_153 VPWR VGND VPWR VGND sky130_fd_sc_hd__decap_3
XFILLER_0_22_197 VPWR VGND VPWR VGND sky130_fd_sc_hd__decap_3
XFILLER_0_9_125 VPWR VGND VPWR VGND sky130_fd_sc_hd__decap_3
XFILLER_0_9_158 VPWR VGND VPWR VGND sky130_fd_sc_hd__decap_3
XFILLER_0_9_169 VPWR VGND VPWR VGND sky130_fd_sc_hd__decap_3
Xpn.column\[1\].fa.fa VPWR VGND VGND VPWR pn.column\[1\].fa.b pn.column\[1\].fa.co
+ pn.column\[1\].fa.a pn.column\[1\].fa.ci pn.column\[1\].fa.sum sky130_fd_sc_hd__fa_1
X_330_ delay2[10] clknet_2_0__leaf_g_delay.gclk delay2[11] VPWR VGND VPWR VGND sky130_fd_sc_hd__dfxtp_1
X_192_ VPWR VGND VGND VPWR _076_ _025_ phase[1] sampled phase[0] sky130_fd_sc_hd__nand4b_1
X_261_ VGND VPWR VPWR VGND sync[7] pn.column\[2\].fa.b prev[7] sky130_fd_sc_hd__xor2_1
X_459_ sync[29] clknet_4_2_0_clk meta[29] VPWR VGND VPWR VGND sky130_fd_sc_hd__dfxtp_1
XFILLER_0_12_53 VPWR VGND VPWR VGND sky130_fd_sc_hd__decap_3
XFILLER_0_2_312 VPWR VGND VPWR VGND sky130_fd_sc_hd__decap_3
XFILLER_0_10_112 VPWR VGND VPWR VGND sky130_fd_sc_hd__decap_3
XFILLER_0_12_97 VPWR VGND VPWR VGND sky130_fd_sc_hd__decap_3
XFILLER_0_10_156 VPWR VGND VPWR VGND sky130_fd_sc_hd__decap_3
XFILLER_0_10_189 VPWR VGND VPWR VGND sky130_fd_sc_hd__decap_3
Xbit_store\[7\].ff VPWR VGND work[7] clknet_1_1__leaf_g_work.gclk work[8] capture
+ net26 VPWR VGND sky130_fd_sc_hd__sdfxtp_1
XFILLER_0_33_259 VPWR VGND VPWR VGND sky130_fd_sc_hd__decap_3
XFILLER_0_33_215 VPWR VGND VPWR VGND sky130_fd_sc_hd__decap_3
Xclkbuf_4_2_0_clk VGND VPWR clknet_0_clk clknet_4_2_0_clk VPWR VGND sky130_fd_sc_hd__clkbuf_4
Xpn.f3.fa VPWR VGND VGND VPWR pn.column\[4\].fa.co pn.f3.co pn.column\[3\].fa.co pn.f0.co
+ pn.f3.sum sky130_fd_sc_hd__fa_1
X_313_ delay1[14] clknet_2_1__leaf_g_delay.gclk delay1[15] VPWR VGND VPWR VGND sky130_fd_sc_hd__dfxtp_1
X_244_ VPWR VGND VGND VPWR vp.count[0] _103_ vp.count[1] sky130_fd_sc_hd__nand2_1
X_175_ VPWR VGND VGND VPWR capture g_delay.en _064_ sky130_fd_sc_hd__nor2_1
Xadd1.bit_add\[18\].fa.fa VPWR VGND VGND VPWR add1.bit_add\[10\].fa.b add1.bit_add\[18\].fa.co
+ add1.bit_add\[18\].fa.a add1.bit_add\[17\].fa.co add1.bit_add\[18\].fa.sum sky130_fd_sc_hd__fa_1
XFILLER_0_2_197 VPWR VGND VPWR VGND sky130_fd_sc_hd__decap_3
XFILLER_0_3_51 VPWR VGND VPWR VGND sky130_fd_sc_hd__decap_3
XFILLER_0_29_307 VPWR VGND VPWR VGND sky130_fd_sc_hd__decap_3
X_227_ VPWR VGND VGND VPWR _095_ debug[6] _011_ sky130_fd_sc_hd__nor2_2
XFILLER_0_8_18 VPWR VGND VPWR VGND sky130_fd_sc_hd__decap_3
XFILLER_0_8_29 VPWR VGND VPWR VGND sky130_fd_sc_hd__decap_3
X_158_ VPWR VGND VGND VPWR phase[6] phase[7] _051_ sky130_fd_sc_hd__nor2_1
XFILLER_0_33_9 VPWR VGND VPWR VGND sky130_fd_sc_hd__decap_3
XFILLER_0_11_240 VPWR VGND VPWR VGND sky130_fd_sc_hd__decap_3
XFILLER_0_11_273 VPWR VGND VPWR VGND sky130_fd_sc_hd__decap_3
XFILLER_0_11_284 VPWR VGND VPWR VGND sky130_fd_sc_hd__decap_3
Xclkbuf_1_1__f_tap_n[0] VGND VPWR clknet_0_tap_n[0] clknet_1_1__leaf_tap_n[0] VPWR
+ VGND sky130_fd_sc_hd__clkbuf_4
Xhold6 net13 add2.bit_add\[15\].fa.a VPWR VGND VGND VPWR sky130_fd_sc_hd__dlygate4sd3_1
XFILLER_0_20_64 VPWR VGND VPWR VGND sky130_fd_sc_hd__decap_3
XPHY_EDGE_ROW_3_Right_3 VPWR VGND VPWR VGND sky130_fd_sc_hd__decap_3
XFILLER_0_0_85 VPWR VGND VPWR VGND sky130_fd_sc_hd__decap_3
XFILLER_0_31_302 VPWR VGND VPWR VGND sky130_fd_sc_hd__decap_3
XFILLER_0_3_281 VPWR VGND VPWR VGND sky130_fd_sc_hd__decap_3
XFILLER_0_9_72 VPWR VGND VPWR VGND sky130_fd_sc_hd__decap_3
Xpp.column\[0\].fa.fa VPWR VGND VGND VPWR pp.column\[0\].fa.b pp.column\[0\].fa.co
+ pp.column\[0\].fa.a pp.column\[0\].fa.ci pp.column\[0\].fa.sum sky130_fd_sc_hd__fa_1
X_492_ VGND VPWR VPWR VGND clknet_4_13_0_clk osr_sel run_n rate_sync[0] sky130_fd_sc_hd__dfrtp_1
XFILLER_0_13_302 VPWR VGND VPWR VGND sky130_fd_sc_hd__decap_3
XFILLER_0_0_284 VPWR VGND VPWR VGND sky130_fd_sc_hd__decap_3
XFILLER_0_0_273 VPWR VGND VPWR VGND sky130_fd_sc_hd__decap_3
XFILLER_0_31_187 VPWR VGND VPWR VGND sky130_fd_sc_hd__decap_3
X_475_ prev[15] clknet_4_0_0_clk sync[15] VPWR VGND VPWR VGND sky130_fd_sc_hd__dfxtp_1
XFILLER_0_10_305 VPWR VGND VPWR VGND sky130_fd_sc_hd__decap_3
XFILLER_0_9_104 VPWR VGND VPWR VGND sky130_fd_sc_hd__decap_3
Xclkbuf_1_1__f_g_work.gclk VGND VPWR clknet_0_g_work.gclk clknet_1_1__leaf_g_work.gclk
+ VPWR VGND sky130_fd_sc_hd__clkbuf_4
X_260_ VGND VPWR VPWR VGND sync[6] pn.column\[2\].fa.a prev[6] sky130_fd_sc_hd__xor2_1
X_191_ VPWR VGND VGND VPWR _075_ _000_ sky130_fd_sc_hd__inv_1
XFILLER_0_8_181 VPWR VGND VPWR VGND sky130_fd_sc_hd__decap_3
X_458_ sync[28] clknet_4_3_0_clk meta[28] VPWR VGND VPWR VGND sky130_fd_sc_hd__dfxtp_1
XFILLER_0_12_21 VPWR VGND VPWR VGND sky130_fd_sc_hd__decap_3
XFILLER_0_12_32 VPWR VGND VPWR VGND sky130_fd_sc_hd__decap_3
XFILLER_0_12_65 VPWR VGND VPWR VGND sky130_fd_sc_hd__decap_3
Xadd1.bit_add\[14\].fa.fa VPWR VGND VGND VPWR add1.bit_add\[10\].fa.b add1.bit_add\[14\].fa.co
+ add1.bit_add\[14\].fa.a add1.bit_add\[13\].fa.co add1.bit_add\[14\].fa.sum sky130_fd_sc_hd__fa_1
X_389_ VGND VPWR VPWR VGND clknet_4_12_0_clk add2.bit_add\[16\].fa.sum cic_n add2.bit_add\[16\].fa.a
+ sky130_fd_sc_hd__dfrtp_1
XFILLER_0_10_124 VPWR VGND VPWR VGND sky130_fd_sc_hd__decap_3
XFILLER_0_10_168 VPWR VGND VPWR VGND sky130_fd_sc_hd__decap_3
X_243_ VPWR VGND VGND VPWR _102_ _079_ _075_ _002_[7] sky130_fd_sc_hd__nor3_1
X_312_ delay1[13] clknet_2_1__leaf_g_delay.gclk delay1[14] VPWR VGND VPWR VGND sky130_fd_sc_hd__dfxtp_1
X_174_ VPWR VGND VGND VPWR _063_ g_delay.en sky130_fd_sc_hd__inv_1
XFILLER_0_3_30 VPWR VGND VPWR VGND sky130_fd_sc_hd__decap_3
Xclkbuf_1_0__f_tap_n[0] VGND VPWR clknet_0_tap_n[0] clknet_1_0__leaf_tap_n[0] VPWR
+ VGND sky130_fd_sc_hd__clkbuf_4
XFILLER_0_21_208 VPWR VGND VPWR VGND sky130_fd_sc_hd__decap_3
X_226_ VPWR VGND VGND VPWR _095_ debug[5] _012_ sky130_fd_sc_hd__nor2_2
X_157_ VPWR VGND VGND VPWR _048_ _050_ _049_ sky130_fd_sc_hd__nand2_1
XFILLER_0_26_9 VPWR VGND VPWR VGND sky130_fd_sc_hd__decap_3
Xclkbuf_4_1_0_clk VGND VPWR clknet_0_clk clknet_4_1_0_clk VPWR VGND sky130_fd_sc_hd__clkbuf_4
XFILLER_0_7_268 VPWR VGND VPWR VGND sky130_fd_sc_hd__decap_3
XFILLER_0_11_252 VPWR VGND VPWR VGND sky130_fd_sc_hd__decap_3
XFILLER_0_11_296 VPWR VGND VPWR VGND sky130_fd_sc_hd__decap_3
Xhold7 net14 add2.bit_add\[3\].fa.a VPWR VGND VGND VPWR sky130_fd_sc_hd__dlygate4sd3_1
XANTENNA__401__D tap_n[1] VGND VPWR VPWR VGND sky130_fd_sc_hd__diode_2
XFILLER_0_29_116 VPWR VGND VPWR VGND sky130_fd_sc_hd__decap_3
XFILLER_0_29_105 VPWR VGND VPWR VGND sky130_fd_sc_hd__decap_3
X_209_ VPWR VGND VGND VPWR _087_ _082_ _012_ pn.f4.sum sky130_fd_sc_hd__maj3_1
XPHY_EDGE_ROW_29_Left_63 VPWR VGND VPWR VGND sky130_fd_sc_hd__decap_3
XFILLER_0_25_311 VPWR VGND VPWR VGND sky130_fd_sc_hd__decap_3
XFILLER_0_4_238 VPWR VGND VPWR VGND sky130_fd_sc_hd__decap_3
XFILLER_0_20_21 VPWR VGND VPWR VGND sky130_fd_sc_hd__decap_3
XFILLER_0_20_76 VPWR VGND VPWR VGND sky130_fd_sc_hd__decap_3
XPHY_EDGE_ROW_13_Left_47 VPWR VGND VPWR VGND sky130_fd_sc_hd__decap_3
Xbit_store\[20\].ff VPWR VGND work[20] clknet_1_0__leaf_g_work.gclk second capture
+ net18 VPWR VGND sky130_fd_sc_hd__sdfxtp_1
XFILLER_0_28_193 VPWR VGND VPWR VGND sky130_fd_sc_hd__decap_3
XFILLER_0_9_51 VPWR VGND VPWR VGND sky130_fd_sc_hd__decap_3
XFILLER_0_31_314 VPWR VGND VPWR VGND sky130_fd_sc_hd__decap_3
X_491_ VGND VPWR VPWR VGND clknet_4_5_0_clk clear_sync[0] run_n clear_sync[1] sky130_fd_sc_hd__dfrtp_1
XFILLER_0_1_219 VPWR VGND VPWR VGND sky130_fd_sc_hd__decap_3
XPHY_EDGE_ROW_13_Right_13 VPWR VGND VPWR VGND sky130_fd_sc_hd__decap_3
XFILLER_0_25_152 VPWR VGND VPWR VGND sky130_fd_sc_hd__decap_3
XPHY_EDGE_ROW_22_Right_22 VPWR VGND VPWR VGND sky130_fd_sc_hd__decap_3
XFILLER_0_25_163 VPWR VGND VPWR VGND sky130_fd_sc_hd__decap_3
XFILLER_0_13_314 VPWR VGND VPWR VGND sky130_fd_sc_hd__decap_3
XPHY_EDGE_ROW_31_Right_31 VPWR VGND VPWR VGND sky130_fd_sc_hd__decap_3
XFILLER_0_22_3 VPWR VGND VPWR VGND sky130_fd_sc_hd__decap_3
XFILLER_0_16_141 VPWR VGND VPWR VGND sky130_fd_sc_hd__decap_3
X_474_ prev[14] clknet_4_10_0_clk sync[14] VPWR VGND VPWR VGND sky130_fd_sc_hd__dfxtp_1
Xadd1.bit_add\[10\].fa.fa VPWR VGND VGND VPWR net1 add1.bit_add\[10\].fa.co add1.bit_add\[10\].fa.a
+ add1.bit_add\[10\].fa.ci add1.bit_add\[10\].fa.sum sky130_fd_sc_hd__fa_1
XFILLER_0_9_116 VPWR VGND VPWR VGND sky130_fd_sc_hd__decap_3
XFILLER_0_13_122 VPWR VGND VPWR VGND sky130_fd_sc_hd__decap_3
XPHY_EDGE_ROW_16_Left_50 VPWR VGND VPWR VGND sky130_fd_sc_hd__decap_3
X_190_ VGND VPWR VGND VPWR _073_ _074_ _075_ sampled sky130_fd_sc_hd__a21oi_4
Xadd2.bit_add\[0\].fa.fa_5 net5 add2.bit_add\[0\].fa.fa_5/HI VPWR VGND VGND VPWR sky130_fd_sc_hd__conb_1
X_457_ sync[27] clknet_4_3_0_clk meta[27] VPWR VGND VPWR VGND sky130_fd_sc_hd__dfxtp_1
XFILLER_0_6_119 VPWR VGND VPWR VGND sky130_fd_sc_hd__decap_3
XFILLER_0_12_44 VPWR VGND VPWR VGND sky130_fd_sc_hd__decap_3
XFILLER_0_12_77 VPWR VGND VPWR VGND sky130_fd_sc_hd__decap_3
XFILLER_0_12_88 VPWR VGND VPWR VGND sky130_fd_sc_hd__decap_3
X_388_ VGND VPWR VPWR VGND clknet_4_12_0_clk add2.bit_add\[15\].fa.sum cic_n add2.bit_add\[15\].fa.a
+ sky130_fd_sc_hd__dfrtp_1
XFILLER_0_10_103 VPWR VGND VPWR VGND sky130_fd_sc_hd__decap_3
XFILLER_0_10_136 VPWR VGND VPWR VGND sky130_fd_sc_hd__decap_3
XFILLER_0_10_147 VPWR VGND VPWR VGND sky130_fd_sc_hd__decap_3
XFILLER_0_33_228 VPWR VGND VPWR VGND sky130_fd_sc_hd__decap_3
XFILLER_0_33_206 VPWR VGND VPWR VGND sky130_fd_sc_hd__decap_3
XPHY_EDGE_ROW_1_Left_35 VPWR VGND VPWR VGND sky130_fd_sc_hd__decap_3
X_242_ VPWR VGND VGND VPWR phase[7] _078_ _102_ sky130_fd_sc_hd__nor2_1
X_173_ VPWR VGND VGND VPWR sampled _063_ _062_ sky130_fd_sc_hd__nand2_1
X_311_ delay1[12] clknet_2_3__leaf_g_delay.gclk delay1[13] VPWR VGND VPWR VGND sky130_fd_sc_hd__dfxtp_1
XANTENNA__404__D tap_n[4] VGND VPWR VPWR VGND sky130_fd_sc_hd__diode_2
XFILLER_0_15_228 VPWR VGND VPWR VGND sky130_fd_sc_hd__decap_3
X_225_ VPWR VGND debug[4] _094_ pp.f1.sum VPWR VGND sky130_fd_sc_hd__and2_1
X_156_ VPWR VGND VGND VPWR phase[5] phase[4] _049_ sky130_fd_sc_hd__nor2_1
XFILLER_0_19_9 VPWR VGND VPWR VGND sky130_fd_sc_hd__decap_3
XFILLER_0_7_225 VPWR VGND VPWR VGND sky130_fd_sc_hd__decap_3
XFILLER_0_11_220 VPWR VGND VPWR VGND sky130_fd_sc_hd__decap_3
XFILLER_0_11_231 VPWR VGND VPWR VGND sky130_fd_sc_hd__decap_3
XFILLER_0_11_264 VPWR VGND VPWR VGND sky130_fd_sc_hd__decap_3
Xhold8 net15 add2.bit_add\[18\].fa.a VPWR VGND VGND VPWR sky130_fd_sc_hd__dlygate4sd3_1
XFILLER_0_4_206 VPWR VGND VPWR VGND sky130_fd_sc_hd__decap_3
X_208_ VPWR VGND VGND VPWR _084_ _086_ add1.bit_add\[1\].fa.b sky130_fd_sc_hd__nor2_1
X_139_ VPWR VGND VGND VPWR _022_ _031_ _032_ sky130_fd_sc_hd__nor2_1
XFILLER_0_20_55 VPWR VGND VPWR VGND sky130_fd_sc_hd__decap_3
XFILLER_0_20_88 VPWR VGND VPWR VGND sky130_fd_sc_hd__decap_3
XFILLER_0_0_21 VPWR VGND VPWR VGND sky130_fd_sc_hd__decap_3
XFILLER_0_0_32 VPWR VGND VPWR VGND sky130_fd_sc_hd__decap_3
XFILLER_0_17_6 VPWR VGND VPWR VGND sky130_fd_sc_hd__decap_3
XFILLER_0_9_30 VPWR VGND VPWR VGND sky130_fd_sc_hd__decap_3
XFILLER_0_9_63 VPWR VGND VPWR VGND sky130_fd_sc_hd__decap_3
XFILLER_0_16_312 VPWR VGND VPWR VGND sky130_fd_sc_hd__decap_3
XFILLER_0_8_9 VPWR VGND VPWR VGND sky130_fd_sc_hd__decap_3
X_490_ VGND VPWR VPWR VGND clknet_4_4_0_clk err_clr run_n clear_sync[0] sky130_fd_sc_hd__dfrtp_1
XFILLER_0_19_172 VPWR VGND VPWR VGND sky130_fd_sc_hd__decap_3
XPHY_EDGE_ROW_30_Left_64 VPWR VGND VPWR VGND sky130_fd_sc_hd__decap_3
Xclkbuf_4_0_0_clk VGND VPWR clknet_0_clk clknet_4_0_0_clk VPWR VGND sky130_fd_sc_hd__clkbuf_4
XANTENNA__412__D tap_n[12] VGND VPWR VPWR VGND sky130_fd_sc_hd__diode_2
XFILLER_0_25_175 VPWR VGND VPWR VGND sky130_fd_sc_hd__decap_3
XFILLER_0_25_197 VPWR VGND VPWR VGND sky130_fd_sc_hd__decap_3
XFILLER_0_15_3 VPWR VGND VPWR VGND sky130_fd_sc_hd__decap_3
XANTENNA__500__RESET_B rst_n VGND VPWR VPWR VGND sky130_fd_sc_hd__diode_2
XFILLER_0_16_153 VPWR VGND VPWR VGND sky130_fd_sc_hd__decap_3
XFILLER_0_6_6 VPWR VGND VPWR VGND sky130_fd_sc_hd__decap_3
X_473_ prev[13] clknet_4_11_0_clk sync[13] VPWR VGND VPWR VGND sky130_fd_sc_hd__dfxtp_1
XANTENNA__407__D tap_n[7] VGND VPWR VPWR VGND sky130_fd_sc_hd__diode_2
Xbit_store\[10\].ff VPWR VGND work[10] clknet_1_1__leaf_g_work.gclk work[11] capture
+ net21 VPWR VGND sky130_fd_sc_hd__sdfxtp_1
XFILLER_0_22_178 VPWR VGND VPWR VGND sky130_fd_sc_hd__decap_3
XFILLER_0_9_128 VPWR VGND VPWR VGND sky130_fd_sc_hd__decap_3
XFILLER_0_5_312 VPWR VGND VPWR VGND sky130_fd_sc_hd__decap_3
Xadd2.bit_add\[6\].fa.fa VPWR VGND VGND VPWR add1.bit_add\[6\].fa.a add2.bit_add\[6\].fa.co
+ add2.bit_add\[6\].fa.a add2.bit_add\[5\].fa.co add2.bit_add\[6\].fa.sum sky130_fd_sc_hd__fa_1
X_456_ sync[26] clknet_4_2_0_clk meta[26] VPWR VGND VPWR VGND sky130_fd_sc_hd__dfxtp_1
XFILLER_0_12_12 VPWR VGND VPWR VGND sky130_fd_sc_hd__decap_3
XFILLER_0_12_56 VPWR VGND VPWR VGND sky130_fd_sc_hd__decap_3
X_387_ VGND VPWR VPWR VGND clknet_4_12_0_clk add2.bit_add\[14\].fa.sum net2 add2.bit_add\[14\].fa.a
+ sky130_fd_sc_hd__dfrtp_1
XFILLER_0_10_115 VPWR VGND VPWR VGND sky130_fd_sc_hd__decap_3
XFILLER_0_10_159 VPWR VGND VPWR VGND sky130_fd_sc_hd__decap_3
XFILLER_0_33_218 VPWR VGND VPWR VGND sky130_fd_sc_hd__decap_3
X_310_ delay1[11] clknet_2_1__leaf_g_delay.gclk delay1[12] VPWR VGND VPWR VGND sky130_fd_sc_hd__dfxtp_1
X_241_ VPWR VGND VGND VPWR _101_ _078_ _075_ _002_[6] sky130_fd_sc_hd__nor3_1
X_172_ VPWR VGND VGND VPWR phase[3] _059_ _056_ _062_ _058_ _060_ sky130_fd_sc_hd__o32ai_1
XFILLER_0_24_207 VPWR VGND VPWR VGND sky130_fd_sc_hd__decap_3
XFILLER_0_17_281 VPWR VGND VPWR VGND sky130_fd_sc_hd__decap_3
XANTENNA__420__D tap_p[5] VGND VPWR VPWR VGND sky130_fd_sc_hd__diode_2
X_439_ sync[9] clknet_4_11_0_clk meta[9] VPWR VGND VPWR VGND sky130_fd_sc_hd__dfxtp_1
XFILLER_0_2_189 VPWR VGND VPWR VGND sky130_fd_sc_hd__decap_3
XFILLER_0_3_21 VPWR VGND VPWR VGND sky130_fd_sc_hd__decap_3
X_224_ VPWR VGND VGND VPWR _095_ debug[3] _013_ sky130_fd_sc_hd__nor2_2
X_155_ VGND VPWR VGND VPWR _048_ _047_ rate _033_ _020_ _046_ sky130_fd_sc_hd__o221ai_2
XFILLER_0_11_243 VPWR VGND VPWR VGND sky130_fd_sc_hd__decap_3
XFILLER_0_11_276 VPWR VGND VPWR VGND sky130_fd_sc_hd__decap_3
XFILLER_0_11_287 VPWR VGND VPWR VGND sky130_fd_sc_hd__decap_3
XFILLER_0_19_310 VPWR VGND VPWR VGND sky130_fd_sc_hd__decap_3
Xhold9 net16 add2.bit_add\[17\].fa.a VPWR VGND VGND VPWR sky130_fd_sc_hd__dlygate4sd3_1
X_207_ VPWR VGND VGND VPWR valid[3] _086_ _085_ sky130_fd_sc_hd__nand2_1
XFILLER_0_20_12 VPWR VGND VPWR VGND sky130_fd_sc_hd__decap_3
XFILLER_0_20_67 VPWR VGND VPWR VGND sky130_fd_sc_hd__decap_3
X_138_ VPWR VGND VGND VPWR work[14] _031_ work[13] phase[2] sky130_fd_sc_hd__mux2i_1
XFILLER_0_31_305 VPWR VGND VPWR VGND sky130_fd_sc_hd__decap_3
XFILLER_0_9_42 VPWR VGND VPWR VGND sky130_fd_sc_hd__decap_3
XFILLER_0_9_75 VPWR VGND VPWR VGND sky130_fd_sc_hd__decap_3
XFILLER_0_3_284 VPWR VGND VPWR VGND sky130_fd_sc_hd__decap_3
XFILLER_0_15_12 VPWR VGND VPWR VGND sky130_fd_sc_hd__decap_3
XFILLER_0_31_88 VPWR VGND VPWR VGND sky130_fd_sc_hd__decap_3
XFILLER_0_13_305 VPWR VGND VPWR VGND sky130_fd_sc_hd__decap_3
XFILLER_0_0_287 VPWR VGND VPWR VGND sky130_fd_sc_hd__decap_3
XFILLER_0_0_276 VPWR VGND VPWR VGND sky130_fd_sc_hd__decap_3
XPHY_EDGE_ROW_7_Right_7 VPWR VGND VPWR VGND sky130_fd_sc_hd__decap_3
XFILLER_0_31_135 VPWR VGND VPWR VGND sky130_fd_sc_hd__decap_3
Xadd2.bit_add\[2\].fa.fa VPWR VGND VGND VPWR add1.bit_add\[2\].fa.a add2.bit_add\[2\].fa.co
+ add2.bit_add\[2\].fa.a add2.bit_add\[1\].fa.co add2.bit_add\[2\].fa.sum sky130_fd_sc_hd__fa_1
X_472_ prev[12] clknet_4_10_0_clk sync[12] VPWR VGND VPWR VGND sky130_fd_sc_hd__dfxtp_1
XANTENNA__423__D tap_p[8] VGND VPWR VPWR VGND sky130_fd_sc_hd__diode_2
XFILLER_0_9_107 VPWR VGND VPWR VGND sky130_fd_sc_hd__decap_3
XFILLER_0_6_21 VPWR VGND VPWR VGND sky130_fd_sc_hd__decap_3
XFILLER_0_13_102 VPWR VGND VPWR VGND sky130_fd_sc_hd__decap_3
XFILLER_0_13_113 VPWR VGND VPWR VGND sky130_fd_sc_hd__decap_3
XFILLER_0_8_184 VPWR VGND VPWR VGND sky130_fd_sc_hd__decap_3
X_455_ sync[25] clknet_4_3_0_clk meta[25] VPWR VGND VPWR VGND sky130_fd_sc_hd__dfxtp_1
XANTENNA__418__D tap_p[3] VGND VPWR VPWR VGND sky130_fd_sc_hd__diode_2
XFILLER_0_12_24 VPWR VGND VPWR VGND sky130_fd_sc_hd__decap_3
XFILLER_0_12_35 VPWR VGND VPWR VGND sky130_fd_sc_hd__decap_3
X_386_ VGND VPWR VPWR VGND clknet_4_12_0_clk add2.bit_add\[13\].fa.sum net2 add2.bit_add\[13\].fa.a
+ sky130_fd_sc_hd__dfrtp_1
XFILLER_0_12_68 VPWR VGND VPWR VGND sky130_fd_sc_hd__decap_3
XFILLER_0_10_127 VPWR VGND VPWR VGND sky130_fd_sc_hd__decap_3
X_240_ VGND VPWR VPWR VGND _077_ phase[4] phase[5] _101_ phase[6] sky130_fd_sc_hd__a31oi_1
X_171_ VPWR VGND VGND VPWR phase[3] _060_ _061_ sky130_fd_sc_hd__nor2_1
X_438_ sync[8] clknet_4_11_0_clk meta[8] VPWR VGND VPWR VGND sky130_fd_sc_hd__dfxtp_1
X_369_ VGND VPWR VPWR VGND clknet_4_6_0_clk add1.bit_add\[17\].fa.sum net3 add1.bit_add\[17\].fa.a
+ sky130_fd_sc_hd__dfrtp_1
X_507_ VGND VPWR VPWR VGND clknet_1_0__leaf_vn.cg.gclk _112_[5] rst_n vn.divided sky130_fd_sc_hd__dfrtp_1
XFILLER_0_2_179 VPWR VGND VPWR VGND sky130_fd_sc_hd__decap_3
XFILLER_0_14_230 VPWR VGND VPWR VGND sky130_fd_sc_hd__decap_3
XFILLER_0_14_296 VPWR VGND VPWR VGND sky130_fd_sc_hd__decap_3
X_223_ VPWR VGND debug[2] _094_ pn.f5.sum VPWR VGND sky130_fd_sc_hd__and2_1
X_154_ VPWR VGND VPWR VGND work[10] _026_ _047_ work[9] _025_ sky130_fd_sc_hd__a22oi_1
XFILLER_0_18_12 VPWR VGND VPWR VGND sky130_fd_sc_hd__decap_3
XFILLER_0_11_211 VPWR VGND VPWR VGND sky130_fd_sc_hd__decap_3
XFILLER_0_11_255 VPWR VGND VPWR VGND sky130_fd_sc_hd__decap_3
XFILLER_0_11_299 VPWR VGND VPWR VGND sky130_fd_sc_hd__decap_3
XFILLER_0_29_108 VPWR VGND VPWR VGND sky130_fd_sc_hd__decap_3
X_206_ VPWR VGND VGND VPWR _082_ _085_ _083_ sky130_fd_sc_hd__nand2_1
X_137_ VGND VPWR VGND VPWR _019_ _027_ _030_ _029_ sky130_fd_sc_hd__o21ai_0
XFILLER_0_25_314 VPWR VGND VPWR VGND sky130_fd_sc_hd__decap_3
XANTENNA__426__D tap_p[11] VGND VPWR VPWR VGND sky130_fd_sc_hd__diode_2
XFILLER_0_20_79 VPWR VGND VPWR VGND sky130_fd_sc_hd__decap_3
XFILLER_0_0_12 VPWR VGND VPWR VGND sky130_fd_sc_hd__decap_3
XFILLER_0_16_303 VPWR VGND VPWR VGND sky130_fd_sc_hd__decap_3
XFILLER_0_9_21 VPWR VGND VPWR VGND sky130_fd_sc_hd__decap_3
XFILLER_0_9_98 VPWR VGND VPWR VGND sky130_fd_sc_hd__decap_3
XFILLER_0_22_6 VPWR VGND VPWR VGND sky130_fd_sc_hd__decap_3
XFILLER_0_16_144 VPWR VGND VPWR VGND sky130_fd_sc_hd__decap_3
X_471_ prev[11] clknet_4_11_0_clk sync[11] VPWR VGND VPWR VGND sky130_fd_sc_hd__dfxtp_1
XFILLER_0_22_147 VPWR VGND VPWR VGND sky130_fd_sc_hd__decap_3
XFILLER_0_30_191 VPWR VGND VPWR VGND sky130_fd_sc_hd__decap_3
XFILLER_0_10_309 VPWR VGND VPWR VGND sky130_fd_sc_hd__decap_3
XFILLER_0_9_119 VPWR VGND VPWR VGND sky130_fd_sc_hd__decap_3
XFILLER_0_13_125 VPWR VGND VPWR VGND sky130_fd_sc_hd__decap_3
XFILLER_0_20_3 VPWR VGND VPWR VGND sky130_fd_sc_hd__decap_3
XFILLER_0_12_180 VPWR VGND VPWR VGND sky130_fd_sc_hd__decap_3
X_454_ sync[24] clknet_4_3_0_clk meta[24] VPWR VGND VPWR VGND sky130_fd_sc_hd__dfxtp_1
XFILLER_0_12_47 VPWR VGND VPWR VGND sky130_fd_sc_hd__decap_3
X_385_ VGND VPWR VPWR VGND clknet_4_14_0_clk add2.bit_add\[12\].fa.sum net2 add2.bit_add\[12\].fa.a
+ sky130_fd_sc_hd__dfrtp_1
XFILLER_0_10_106 VPWR VGND VPWR VGND sky130_fd_sc_hd__decap_3
XFILLER_0_33_209 VPWR VGND VPWR VGND sky130_fd_sc_hd__decap_3
XFILLER_0_18_228 VPWR VGND VPWR VGND sky130_fd_sc_hd__decap_3
X_170_ VGND VPWR _060_ phase[1] phase[0] phase[2] VPWR VGND sky130_fd_sc_hd__and3_1
XFILLER_0_32_297 VPWR VGND VPWR VGND sky130_fd_sc_hd__decap_3
XFILLER_0_17_261 VPWR VGND VPWR VGND sky130_fd_sc_hd__decap_3
XANTENNA__429__D tap_p[14] VGND VPWR VPWR VGND sky130_fd_sc_hd__diode_2
X_506_ VGND VPWR VPWR VGND clknet_1_0__leaf_vn.cg.gclk _112_[4] rst_n vn.count[4]
+ sky130_fd_sc_hd__dfrtp_1
X_299_ delay1[0] clknet_2_3__leaf_g_delay.gclk delay1[1] VPWR VGND VPWR VGND sky130_fd_sc_hd__dfxtp_1
X_437_ sync[7] clknet_4_10_0_clk meta[7] VPWR VGND VPWR VGND sky130_fd_sc_hd__dfxtp_1
X_368_ VGND VPWR VPWR VGND clknet_4_6_0_clk add1.bit_add\[16\].fa.sum cic_n add1.bit_add\[16\].fa.a
+ sky130_fd_sc_hd__dfrtp_1
XFILLER_0_3_12 VPWR VGND VPWR VGND sky130_fd_sc_hd__decap_3
XPHY_EDGE_ROW_5_Left_39 VPWR VGND VPWR VGND sky130_fd_sc_hd__decap_3
XFILLER_0_14_253 VPWR VGND VPWR VGND sky130_fd_sc_hd__decap_3
XPHY_EDGE_ROW_29_Right_29 VPWR VGND VPWR VGND sky130_fd_sc_hd__decap_3
X_222_ VPWR VGND VPWR VGND pn.f4.sum _094_ vn.divided vn.cg.en debug[1] sky130_fd_sc_hd__a22o_2
X_153_ VPWR VGND VGND VPWR phase[3] _046_ _045_ sky130_fd_sc_hd__nand2_1
XFILLER_0_28_312 VPWR VGND VPWR VGND sky130_fd_sc_hd__decap_3
XFILLER_0_7_228 VPWR VGND VPWR VGND sky130_fd_sc_hd__decap_3
XFILLER_0_11_234 VPWR VGND VPWR VGND sky130_fd_sc_hd__decap_3
XFILLER_0_11_267 VPWR VGND VPWR VGND sky130_fd_sc_hd__decap_3
X_205_ VPWR VGND VGND VPWR _082_ _083_ _084_ sky130_fd_sc_hd__nor2_1
X_136_ VPWR VGND VGND VPWR _022_ _023_ _028_ _021_ _029_ sky130_fd_sc_hd__o22ai_1
XFILLER_0_20_58 VPWR VGND VPWR VGND sky130_fd_sc_hd__decap_3
Xbit_store\[13\].ff VPWR VGND work[13] clknet_1_1__leaf_g_work.gclk work[14] capture
+ net9 VPWR VGND sky130_fd_sc_hd__sdfxtp_1
XFILLER_0_29_12 VPWR VGND VPWR VGND sky130_fd_sc_hd__decap_3
XFILLER_0_17_9 VPWR VGND VPWR VGND sky130_fd_sc_hd__decap_3
XFILLER_0_28_120 VPWR VGND VPWR VGND sky130_fd_sc_hd__decap_3
XFILLER_0_0_35 VPWR VGND VPWR VGND sky130_fd_sc_hd__decap_3
XFILLER_0_9_33 VPWR VGND VPWR VGND sky130_fd_sc_hd__decap_3
XFILLER_0_9_66 VPWR VGND VPWR VGND sky130_fd_sc_hd__decap_3
XFILLER_0_10_80 VPWR VGND VPWR VGND sky130_fd_sc_hd__decap_3
XFILLER_0_10_91 VPWR VGND VPWR VGND sky130_fd_sc_hd__decap_3
XPHY_EDGE_ROW_8_Left_42 VPWR VGND VPWR VGND sky130_fd_sc_hd__decap_3
XFILLER_0_31_57 VPWR VGND VPWR VGND sky130_fd_sc_hd__decap_3
XFILLER_0_25_178 VPWR VGND VPWR VGND sky130_fd_sc_hd__decap_3
XFILLER_0_0_245 VPWR VGND VPWR VGND sky130_fd_sc_hd__decap_3
X_119_ VPWR VGND VGND VPWR vn.count[0] _111_[0] sky130_fd_sc_hd__inv_1
XFILLER_0_8_312 VPWR VGND VPWR VGND sky130_fd_sc_hd__decap_3
XFILLER_0_15_6 VPWR VGND VPWR VGND sky130_fd_sc_hd__decap_3
XFILLER_0_16_101 VPWR VGND VPWR VGND sky130_fd_sc_hd__decap_3
XFILLER_0_6_9 VPWR VGND VPWR VGND sky130_fd_sc_hd__decap_3
Xbit_store\[0\].ff VPWR VGND a clknet_1_0__leaf_g_work.gclk shift_word[0] capture
+ net25 VPWR VGND sky130_fd_sc_hd__sdfxtp_1
X_470_ prev[10] clknet_4_11_0_clk sync[10] VPWR VGND VPWR VGND sky130_fd_sc_hd__dfxtp_1
XFILLER_0_22_137 VPWR VGND VPWR VGND sky130_fd_sc_hd__decap_3
XFILLER_0_6_12 VPWR VGND VPWR VGND sky130_fd_sc_hd__decap_3
XFILLER_0_8_131 VPWR VGND VPWR VGND sky130_fd_sc_hd__decap_3
XFILLER_0_29_292 VPWR VGND VPWR VGND sky130_fd_sc_hd__decap_3
XFILLER_0_8_175 VPWR VGND VPWR VGND sky130_fd_sc_hd__decap_3
XFILLER_0_12_192 VPWR VGND VPWR VGND sky130_fd_sc_hd__decap_3
X_453_ sync[23] clknet_4_1_0_clk meta[23] VPWR VGND VPWR VGND sky130_fd_sc_hd__dfxtp_1
XFILLER_0_12_15 VPWR VGND VPWR VGND sky130_fd_sc_hd__decap_3
XFILLER_0_12_59 VPWR VGND VPWR VGND sky130_fd_sc_hd__decap_3
X_384_ VGND VPWR VPWR VGND clknet_4_14_0_clk add2.bit_add\[11\].fa.sum net2 add2.bit_add\[11\].fa.a
+ sky130_fd_sc_hd__dfrtp_1
XFILLER_0_10_118 VPWR VGND VPWR VGND sky130_fd_sc_hd__decap_3
XFILLER_0_2_3 VPWR VGND VPWR VGND sky130_fd_sc_hd__decap_3
XFILLER_0_17_284 VPWR VGND VPWR VGND sky130_fd_sc_hd__decap_3
X_436_ sync[6] clknet_4_10_0_clk meta[6] VPWR VGND VPWR VGND sky130_fd_sc_hd__dfxtp_1
X_505_ VGND VPWR VPWR VGND clknet_1_1__leaf_vn.cg.gclk _112_[3] rst_n vn.count[3]
+ sky130_fd_sc_hd__dfrtp_1
X_298_ VGND VPWR VPWR VGND clknet_4_5_0_clk _006_ run_n borrow1 sky130_fd_sc_hd__dfrtp_1
X_367_ VGND VPWR VPWR VGND clknet_4_9_0_clk add1.bit_add\[15\].fa.sum cic_n add1.bit_add\[15\].fa.a
+ sky130_fd_sc_hd__dfrtp_1
XPHY_EDGE_ROW_21_Left_55 VPWR VGND VPWR VGND sky130_fd_sc_hd__decap_3
XFILLER_0_3_57 VPWR VGND VPWR VGND sky130_fd_sc_hd__decap_3
XFILLER_0_3_24 VPWR VGND VPWR VGND sky130_fd_sc_hd__decap_3
X_221_ VPWR VGND VPWR VGND _094_ vp.divided vn.cg.en debug[0] pn.f1.sum sky130_fd_sc_hd__a22o_1
X_152_ VGND VPWR VGND VPWR work[10] work[8] rate work[9] work[7] phase[2] _045_ sky130_fd_sc_hd__mux4_1
X_396__6 _396__6/LO net6 VPWR VGND VGND VPWR sky130_fd_sc_hd__conb_1
X_419_ meta[19] clknet_4_1_0_clk tap_p[4] VPWR VGND VPWR VGND sky130_fd_sc_hd__dfxtp_1
XFILLER_0_11_202 VPWR VGND VPWR VGND sky130_fd_sc_hd__decap_3
XFILLER_0_11_246 VPWR VGND VPWR VGND sky130_fd_sc_hd__decap_3
XANTENNA__503__RESET_B rst_n VGND VPWR VPWR VGND sky130_fd_sc_hd__diode_2
XFILLER_0_19_313 VPWR VGND VPWR VGND sky130_fd_sc_hd__decap_3
X_204_ VGND VPWR VPWR VGND pp.f4.sum _083_ pn.f4.sum sky130_fd_sc_hd__xor2_1
XFILLER_0_20_15 VPWR VGND VPWR VGND sky130_fd_sc_hd__decap_3
X_135_ VGND VPWR VPWR VGND phase[2] work[16] work[15] _028_ sky130_fd_sc_hd__mux2i_2
XFILLER_0_29_57 VPWR VGND VPWR VGND sky130_fd_sc_hd__decap_3
Xmax_cap1 net1 add1.bit_add\[10\].fa.b VPWR VGND VGND VPWR sky130_fd_sc_hd__clkbuf_8
XFILLER_0_31_308 VPWR VGND VPWR VGND sky130_fd_sc_hd__decap_3
XFILLER_0_9_12 VPWR VGND VPWR VGND sky130_fd_sc_hd__decap_3
XFILLER_0_9_45 VPWR VGND VPWR VGND sky130_fd_sc_hd__decap_3
XFILLER_0_3_287 VPWR VGND VPWR VGND sky130_fd_sc_hd__decap_3
XFILLER_0_3_276 VPWR VGND VPWR VGND sky130_fd_sc_hd__decap_3
XFILLER_0_3_232 VPWR VGND VPWR VGND sky130_fd_sc_hd__decap_3
Xclkbuf_4_15_0_clk VGND VPWR clknet_0_clk clknet_4_15_0_clk VPWR VGND sky130_fd_sc_hd__clkbuf_4
Xadd2.bit_add\[18\].fa.fa VPWR VGND VGND VPWR add1.bit_add\[18\].fa.a add2.bit_add\[18\].fa.co
+ add2.bit_add\[18\].fa.a add2.bit_add\[17\].fa.co add2.bit_add\[18\].fa.sum sky130_fd_sc_hd__fa_1
XANTENNA__496__RESET_B rst_n VGND VPWR VPWR VGND sky130_fd_sc_hd__diode_2
XFILLER_0_15_15 VPWR VGND VPWR VGND sky130_fd_sc_hd__decap_3
XFILLER_0_15_48 VPWR VGND VPWR VGND sky130_fd_sc_hd__decap_3
XFILLER_0_13_308 VPWR VGND VPWR VGND sky130_fd_sc_hd__decap_3
X_118_ VPWR VGND VGND VPWR phase[7] _014_ sky130_fd_sc_hd__inv_1
XFILLER_0_13_105 VPWR VGND VPWR VGND sky130_fd_sc_hd__decap_3
XFILLER_0_13_116 VPWR VGND VPWR VGND sky130_fd_sc_hd__decap_3
XFILLER_0_6_24 VPWR VGND VPWR VGND sky130_fd_sc_hd__decap_3
XFILLER_0_6_46 VPWR VGND VPWR VGND sky130_fd_sc_hd__decap_3
XFILLER_0_8_110 VPWR VGND VPWR VGND sky130_fd_sc_hd__decap_3
XFILLER_0_8_187 VPWR VGND VPWR VGND sky130_fd_sc_hd__decap_3
XFILLER_0_12_171 VPWR VGND VPWR VGND sky130_fd_sc_hd__decap_3
X_452_ sync[22] clknet_4_1_0_clk meta[22] VPWR VGND VPWR VGND sky130_fd_sc_hd__dfxtp_1
X_383_ VGND VPWR VPWR VGND clknet_4_14_0_clk add2.bit_add\[10\].fa.sum net2 add2.bit_add\[10\].fa.a
+ sky130_fd_sc_hd__dfrtp_1
XFILLER_0_12_38 VPWR VGND VPWR VGND sky130_fd_sc_hd__decap_3
XFILLER_0_5_113 VPWR VGND VPWR VGND sky130_fd_sc_hd__decap_3
XFILLER_0_17_252 VPWR VGND VPWR VGND sky130_fd_sc_hd__decap_3
XFILLER_0_4_190 VPWR VGND VPWR VGND sky130_fd_sc_hd__decap_3
X_435_ sync[5] clknet_4_10_0_clk meta[5] VPWR VGND VPWR VGND sky130_fd_sc_hd__dfxtp_1
X_504_ VGND VPWR VPWR VGND clknet_1_1__leaf_vn.cg.gclk _112_[2] rst_n vn.count[2]
+ sky130_fd_sc_hd__dfrtp_1
X_366_ VGND VPWR VPWR VGND clknet_4_9_0_clk add1.bit_add\[14\].fa.sum cic_n add1.bit_add\[14\].fa.a
+ sky130_fd_sc_hd__dfrtp_1
XFILLER_0_23_48 VPWR VGND VPWR VGND sky130_fd_sc_hd__decap_3
X_297_ VGND VPWR VPWR VGND clknet_4_15_0_clk _005_ run_n sdo sky130_fd_sc_hd__dfrtp_2
XFILLER_0_14_299 VPWR VGND VPWR VGND sky130_fd_sc_hd__decap_3
X_220_ VPWR VGND VGND VPWR _095_ _093_ dbg_mode[1] sky130_fd_sc_hd__lpflow_inputiso1p_1
X_151_ VGND VPWR _042_ _043_ _044_ _039_ VPWR VGND sky130_fd_sc_hd__o21ai_1
XFILLER_0_18_15 VPWR VGND VPWR VGND sky130_fd_sc_hd__decap_3
X_349_ VGND VPWR VPWR VGND clknet_4_15_0_clk _002_[5] run_n phase[5] sky130_fd_sc_hd__dfrtp_4
X_418_ meta[18] clknet_4_1_0_clk tap_p[3] VPWR VGND VPWR VGND sky130_fd_sc_hd__dfxtp_1
XFILLER_0_11_214 VPWR VGND VPWR VGND sky130_fd_sc_hd__decap_3
XFILLER_0_11_225 VPWR VGND VPWR VGND sky130_fd_sc_hd__decap_3
XFILLER_0_11_258 VPWR VGND VPWR VGND sky130_fd_sc_hd__decap_3
XFILLER_0_6_241 VPWR VGND VPWR VGND sky130_fd_sc_hd__decap_3
Xadd2.bit_add\[14\].fa.fa VPWR VGND VGND VPWR add1.bit_add\[14\].fa.a add2.bit_add\[14\].fa.co
+ add2.bit_add\[14\].fa.a add2.bit_add\[13\].fa.co add2.bit_add\[14\].fa.sum sky130_fd_sc_hd__fa_1
X_203_ VPWR VGND VGND VPWR _081_ _082_ valid[3] add1.bit_add\[0\].fa.b sky130_fd_sc_hd__o21a_1
X_134_ VPWR VGND VGND VPWR _020_ _024_ _027_ sky130_fd_sc_hd__nor2_1
XFILLER_0_20_49 VPWR VGND VPWR VGND sky130_fd_sc_hd__decap_3
XFILLER_0_0_15 VPWR VGND VPWR VGND sky130_fd_sc_hd__decap_3
Xmax_cap2 net2 cic_n VPWR VGND VGND VPWR sky130_fd_sc_hd__clkbuf_8
XFILLER_0_9_24 VPWR VGND VPWR VGND sky130_fd_sc_hd__decap_3
XFILLER_0_9_57 VPWR VGND VPWR VGND sky130_fd_sc_hd__decap_3
XFILLER_0_10_71 VPWR VGND VPWR VGND sky130_fd_sc_hd__decap_3
XFILLER_0_19_91 VPWR VGND VPWR VGND sky130_fd_sc_hd__decap_3
XFILLER_0_19_122 VPWR VGND VPWR VGND sky130_fd_sc_hd__decap_3
XFILLER_0_22_309 VPWR VGND VPWR VGND sky130_fd_sc_hd__decap_3
X_117_ VPWR VGND VGND VPWR pn.f5.co _013_ sky130_fd_sc_hd__inv_1
XFILLER_0_25_169 VPWR VGND VPWR VGND sky130_fd_sc_hd__decap_3
XFILLER_0_22_9 VPWR VGND VPWR VGND sky130_fd_sc_hd__decap_3
XFILLER_0_16_147 VPWR VGND VPWR VGND sky130_fd_sc_hd__decap_3
X_494__7 _494__7/LO net7 VPWR VGND VGND VPWR sky130_fd_sc_hd__conb_1
XFILLER_0_13_128 VPWR VGND VPWR VGND sky130_fd_sc_hd__decap_3
Xclkbuf_2_0__f_g_delay.gclk VGND VPWR clknet_0_g_delay.gclk clknet_2_0__leaf_g_delay.gclk
+ VPWR VGND sky130_fd_sc_hd__clkbuf_4
Xclkbuf_4_14_0_clk VGND VPWR clknet_0_clk clknet_4_14_0_clk VPWR VGND sky130_fd_sc_hd__clkbuf_4
XFILLER_0_20_6 VPWR VGND VPWR VGND sky130_fd_sc_hd__decap_3
XFILLER_0_8_122 VPWR VGND VPWR VGND sky130_fd_sc_hd__decap_3
XFILLER_0_12_150 VPWR VGND VPWR VGND sky130_fd_sc_hd__decap_3
XFILLER_0_12_183 VPWR VGND VPWR VGND sky130_fd_sc_hd__decap_3
X_451_ sync[21] clknet_4_1_0_clk meta[21] VPWR VGND VPWR VGND sky130_fd_sc_hd__dfxtp_1
X_382_ VGND VPWR VPWR VGND clknet_4_14_0_clk add2.bit_add\[9\].fa.sum net2 add2.bit_add\[9\].fa.a
+ sky130_fd_sc_hd__dfrtp_1
XFILLER_0_2_309 VPWR VGND VPWR VGND sky130_fd_sc_hd__decap_3
XFILLER_0_10_109 VPWR VGND VPWR VGND sky130_fd_sc_hd__decap_3
Xadd1.bit_add\[6\].fa.fa VPWR VGND VGND VPWR net1 add1.bit_add\[6\].fa.co add1.bit_add\[6\].fa.a
+ add1.bit_add\[5\].fa.co add1.bit_add\[6\].fa.sum sky130_fd_sc_hd__fa_1
X_503_ VGND VPWR VPWR VGND clknet_1_1__leaf_vn.cg.gclk _112_[1] rst_n vn.count[1]
+ sky130_fd_sc_hd__dfrtp_2
X_296_ VGND VPWR VPWR VGND clknet_4_15_0_clk _003_ run_n sclk sky130_fd_sc_hd__dfrtp_2
X_434_ sync[4] clknet_4_8_0_clk meta[4] VPWR VGND VPWR VGND sky130_fd_sc_hd__dfxtp_1
X_365_ VGND VPWR VPWR VGND clknet_4_9_0_clk add1.bit_add\[13\].fa.sum net2 add1.bit_add\[13\].fa.a
+ sky130_fd_sc_hd__dfrtp_1
Xbit_store\[16\].ff VPWR VGND work[16] clknet_1_0__leaf_g_work.gclk work[17] capture
+ net19 VPWR VGND sky130_fd_sc_hd__sdfxtp_1
XFILLER_0_3_15 VPWR VGND VPWR VGND sky130_fd_sc_hd__decap_3
XFILLER_0_14_256 VPWR VGND VPWR VGND sky130_fd_sc_hd__decap_3
Xpn.column\[4\].fa.fa VPWR VGND VGND VPWR pn.column\[4\].fa.b pn.column\[4\].fa.co
+ pn.column\[4\].fa.a pn.column\[4\].fa.ci pn.column\[4\].fa.sum sky130_fd_sc_hd__fa_1
X_150_ VPWR VGND VGND VPWR phase[4] phase[5] _043_ sky130_fd_sc_hd__lpflow_isobufsrc_1
XFILLER_0_9_261 VPWR VGND VPWR VGND sky130_fd_sc_hd__decap_3
Xadd2.bit_add\[10\].fa.fa VPWR VGND VGND VPWR add1.bit_add\[10\].fa.a add2.bit_add\[10\].fa.co
+ add2.bit_add\[10\].fa.a add2.bit_add\[10\].fa.ci add2.bit_add\[10\].fa.sum sky130_fd_sc_hd__fa_1
Xclkbuf_1_0__f_vp.cg.gclk VGND VPWR clknet_0_vp.cg.gclk clknet_1_0__leaf_vp.cg.gclk
+ VPWR VGND sky130_fd_sc_hd__clkbuf_4
XPHY_EDGE_ROW_16_Right_16 VPWR VGND VPWR VGND sky130_fd_sc_hd__decap_3
X_348_ VGND VPWR VPWR VGND clknet_4_15_0_clk _002_[4] run_n phase[4] sky130_fd_sc_hd__dfrtp_4
XPHY_EDGE_ROW_25_Right_25 VPWR VGND VPWR VGND sky130_fd_sc_hd__decap_3
X_279_ VGND VPWR VPWR VGND sync[25] pp.column\[3\].fa.b prev[25] sky130_fd_sc_hd__xor2_1
X_417_ meta[17] clknet_4_1_0_clk tap_p[2] VPWR VGND VPWR VGND sky130_fd_sc_hd__dfxtp_1
XFILLER_0_11_237 VPWR VGND VPWR VGND sky130_fd_sc_hd__decap_3
XFILLER_0_24_70 VPWR VGND VPWR VGND sky130_fd_sc_hd__decap_3
XFILLER_0_10_292 VPWR VGND VPWR VGND sky130_fd_sc_hd__decap_3
XANTENNA__200__A dbg_mode[1] VGND VPWR VPWR VGND sky130_fd_sc_hd__diode_2
X_202_ VPWR VGND VGND VPWR pn.f1.sum pp.f1.sum _082_ sky130_fd_sc_hd__lpflow_isobufsrc_1
Xbit_store\[3\].ff VPWR VGND work[3] clknet_1_0__leaf_g_work.gclk work[4] capture
+ net14 VPWR VGND sky130_fd_sc_hd__sdfxtp_1
X_133_ VPWR VGND VGND VPWR phase[2] phase[3] _026_ sky130_fd_sc_hd__nor2_1
XFILLER_0_29_15 VPWR VGND VPWR VGND sky130_fd_sc_hd__decap_3
Xmax_cap3 VPWR VGND net3 cic_n VPWR VGND sky130_fd_sc_hd__buf_6
XFILLER_0_28_167 VPWR VGND VPWR VGND sky130_fd_sc_hd__decap_3
XFILLER_0_9_36 VPWR VGND VPWR VGND sky130_fd_sc_hd__decap_3
XFILLER_0_9_69 VPWR VGND VPWR VGND sky130_fd_sc_hd__decap_3
XFILLER_0_10_50 VPWR VGND VPWR VGND sky130_fd_sc_hd__decap_3
XFILLER_0_10_94 VPWR VGND VPWR VGND sky130_fd_sc_hd__decap_3
XFILLER_0_29_3 VPWR VGND VPWR VGND sky130_fd_sc_hd__decap_3
X_116_ VPWR VGND VGND VPWR pp.f4.sum _012_ sky130_fd_sc_hd__inv_1
XFILLER_0_33_192 VPWR VGND VPWR VGND sky130_fd_sc_hd__decap_3
XFILLER_0_0_248 VPWR VGND VPWR VGND sky130_fd_sc_hd__decap_3
XFILLER_0_15_9 VPWR VGND VPWR VGND sky130_fd_sc_hd__decap_3
XFILLER_0_21_60 VPWR VGND VPWR VGND sky130_fd_sc_hd__decap_3
XPHY_EDGE_ROW_2_Right_2 VPWR VGND VPWR VGND sky130_fd_sc_hd__decap_3
XFILLER_0_6_15 VPWR VGND VPWR VGND sky130_fd_sc_hd__decap_3
XFILLER_0_21_162 VPWR VGND VPWR VGND sky130_fd_sc_hd__decap_3
Xadd1.bit_add\[2\].fa.fa VPWR VGND VGND VPWR add1.bit_add\[2\].fa.b add1.bit_add\[2\].fa.co
+ add1.bit_add\[2\].fa.a add1.bit_add\[1\].fa.co add1.bit_add\[2\].fa.sum sky130_fd_sc_hd__fa_1
XFILLER_0_8_101 VPWR VGND VPWR VGND sky130_fd_sc_hd__decap_3
XFILLER_0_29_295 VPWR VGND VPWR VGND sky130_fd_sc_hd__decap_3
XFILLER_0_8_178 VPWR VGND VPWR VGND sky130_fd_sc_hd__decap_3
XFILLER_0_4_9 VPWR VGND VPWR VGND sky130_fd_sc_hd__decap_3
XFILLER_0_12_162 VPWR VGND VPWR VGND sky130_fd_sc_hd__decap_3
Xpp.column\[3\].fa.fa VPWR VGND VGND VPWR pp.column\[3\].fa.b pp.column\[3\].fa.co
+ pp.column\[3\].fa.a pp.column\[3\].fa.ci pp.column\[3\].fa.sum sky130_fd_sc_hd__fa_1
X_450_ sync[20] clknet_4_1_0_clk meta[20] VPWR VGND VPWR VGND sky130_fd_sc_hd__dfxtp_1
XFILLER_0_12_18 VPWR VGND VPWR VGND sky130_fd_sc_hd__decap_3
XFILLER_0_12_29 VPWR VGND VPWR VGND sky130_fd_sc_hd__decap_3
X_381_ VGND VPWR VPWR VGND clknet_4_14_0_clk add2.bit_add\[8\].fa.sum net2 add2.bit_add\[8\].fa.a
+ sky130_fd_sc_hd__dfrtp_1
Xpp.f1.fa VPWR VGND VGND VPWR pp.column\[3\].fa.sum pp.f1.co pp.column\[4\].fa.sum
+ pp.f0.sum pp.f1.sum sky130_fd_sc_hd__fa_2
Xpn.column\[0\].fa.fa VPWR VGND VGND VPWR pn.column\[0\].fa.b pn.column\[0\].fa.co
+ pn.column\[0\].fa.a pn.column\[0\].fa.ci pn.column\[0\].fa.sum sky130_fd_sc_hd__fa_1
XFILLER_0_11_3 VPWR VGND VPWR VGND sky130_fd_sc_hd__decap_3
XFILLER_0_2_6 VPWR VGND VPWR VGND sky130_fd_sc_hd__decap_3
Xclkbuf_4_13_0_clk VGND VPWR clknet_0_clk clknet_4_13_0_clk VPWR VGND sky130_fd_sc_hd__clkbuf_4
X_433_ sync[3] clknet_4_8_0_clk meta[3] VPWR VGND VPWR VGND sky130_fd_sc_hd__dfxtp_1
X_502_ VGND VPWR VPWR VGND clknet_1_0__leaf_vn.cg.gclk _111_[0] rst_n vn.count[0]
+ sky130_fd_sc_hd__dfrtp_2
X_295_ VPWR VGND VPWR VGND cs_n run_n _001_ clknet_4_15_0_clk sky130_fd_sc_hd__dfstp_1
X_364_ VGND VPWR VPWR VGND clknet_4_11_0_clk add1.bit_add\[12\].fa.sum net2 add1.bit_add\[12\].fa.a
+ sky130_fd_sc_hd__dfrtp_1
XFILLER_0_3_27 VPWR VGND VPWR VGND sky130_fd_sc_hd__decap_3
XFILLER_0_13_290 VPWR VGND VPWR VGND sky130_fd_sc_hd__decap_3
XPHY_EDGE_ROW_25_Left_59 VPWR VGND VPWR VGND sky130_fd_sc_hd__decap_3
XFILLER_0_0_3 VPWR VGND VPWR VGND sky130_fd_sc_hd__decap_3
X_416_ meta[16] clknet_4_1_0_clk tap_p[1] VPWR VGND VPWR VGND sky130_fd_sc_hd__dfxtp_1
X_347_ VGND VPWR VPWR VGND clknet_4_15_0_clk _002_[3] run_n phase[3] sky130_fd_sc_hd__dfrtp_4
X_278_ VGND VPWR VPWR VGND sync[24] pp.column\[3\].fa.a prev[24] sky130_fd_sc_hd__xor2_1
XFILLER_0_11_205 VPWR VGND VPWR VGND sky130_fd_sc_hd__decap_3
Xadd1.bit_add\[17\].fa.fa VPWR VGND VGND VPWR add1.bit_add\[10\].fa.b add1.bit_add\[17\].fa.co
+ add1.bit_add\[17\].fa.a add1.bit_add\[16\].fa.co add1.bit_add\[17\].fa.sum sky130_fd_sc_hd__fa_1
XFILLER_0_11_249 VPWR VGND VPWR VGND sky130_fd_sc_hd__decap_3
XFILLER_0_4_70 VPWR VGND VPWR VGND sky130_fd_sc_hd__decap_3
XFILLER_0_10_260 VPWR VGND VPWR VGND sky130_fd_sc_hd__decap_3
X_201_ VPWR VGND VGND VPWR pp.f1.sum pn.f1.sum _081_ sky130_fd_sc_hd__lpflow_isobufsrc_1
XFILLER_0_25_308 VPWR VGND VPWR VGND sky130_fd_sc_hd__decap_3
X_132_ VPWR VGND VGND VPWR phase[2] phase[3] _025_ sky130_fd_sc_hd__lpflow_isobufsrc_1
XFILLER_0_20_18 VPWR VGND VPWR VGND sky130_fd_sc_hd__decap_3
XFILLER_0_9_15 VPWR VGND VPWR VGND sky130_fd_sc_hd__decap_3
Xclkbuf_0_vn.cg.gclk VGND VPWR vn.cg.gclk clknet_0_vn.cg.gclk VPWR VGND sky130_fd_sc_hd__clkbuf_4
XFILLER_0_3_213 VPWR VGND VPWR VGND sky130_fd_sc_hd__decap_3
XFILLER_0_9_48 VPWR VGND VPWR VGND sky130_fd_sc_hd__decap_3
XFILLER_0_10_62 VPWR VGND VPWR VGND sky130_fd_sc_hd__decap_3
X_115_ VPWR VGND VGND VPWR pp.f5.sum _011_ sky130_fd_sc_hd__inv_1
XPHY_EDGE_ROW_28_Left_62 VPWR VGND VPWR VGND sky130_fd_sc_hd__decap_3
XPHY_EDGE_ROW_12_Left_46 VPWR VGND VPWR VGND sky130_fd_sc_hd__decap_3
XFILLER_0_24_193 VPWR VGND VPWR VGND sky130_fd_sc_hd__decap_3
XFILLER_0_24_171 VPWR VGND VPWR VGND sky130_fd_sc_hd__decap_3
Xpp.f4.fa VPWR VGND VGND VPWR pp.f2.sum pp.f4.co pp.f3.sum pp.f1.co pp.f4.sum sky130_fd_sc_hd__fa_2
XFILLER_0_6_49 VPWR VGND VPWR VGND sky130_fd_sc_hd__decap_3
XFILLER_0_13_108 VPWR VGND VPWR VGND sky130_fd_sc_hd__decap_3
XFILLER_0_13_119 VPWR VGND VPWR VGND sky130_fd_sc_hd__decap_3
XFILLER_0_8_113 VPWR VGND VPWR VGND sky130_fd_sc_hd__decap_3
XFILLER_0_16_50 VPWR VGND VPWR VGND sky130_fd_sc_hd__decap_3
XFILLER_0_12_130 VPWR VGND VPWR VGND sky130_fd_sc_hd__decap_3
XFILLER_0_12_141 VPWR VGND VPWR VGND sky130_fd_sc_hd__decap_3
XFILLER_0_12_174 VPWR VGND VPWR VGND sky130_fd_sc_hd__decap_3
X_380_ VGND VPWR VPWR VGND clknet_4_14_0_clk add2.bit_add\[7\].fa.sum net2 add2.bit_add\[7\].fa.a
+ sky130_fd_sc_hd__dfrtp_1
XFILLER_0_26_299 VPWR VGND VPWR VGND sky130_fd_sc_hd__decap_3
XFILLER_0_5_116 VPWR VGND VPWR VGND sky130_fd_sc_hd__decap_3
.ends
