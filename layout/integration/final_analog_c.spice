* NGSPICE file created from eleva_adc_analog.ext - technology: sky130A

.subckt eleva_adc_analog vinp vinn b0 b1 v g p0 p1 p2 p3 p4 p5 p6 p7 p8 p9 p10 p11
+ p12 p13 p14 n0 n1 n2 n3 n4 n5 n6 n7 n8 n9 n10 n11 n12 n13 n14
X0 mid sn g sky130_fd_pr__res_high_po_0p69 l=80
X1 a_18484_23358# nb2 g g sky130_fd_pr__nfet_01v8_lvt ad=3.02 pd=9.51 as=4.2 ps=6.1 w=4 l=0.15
X2 g na4 sky130_fd_pr__cap_mim_m3_1 l=4.5 w=4.5
X3 rp pa14 pa0 v sky130_fd_pr__pfet_01v8_lvt ad=4.41 pd=9.45 as=6.09 ps=18.25 w=8.4 l=0.55
X4 a_1720_21538# a_1089_23358# v v sky130_fd_pr__pfet_01v8 ad=0.6342 pd=3.19 as=0.882 ps=2.94 w=0.84 l=0.15
X5 a_12555_21538# a_11924_23358# g g sky130_fd_pr__nfet_01v8 ad=0.3171 pd=2.35 as=0.441 ps=2.52 w=0.42 l=0.15
X6 v g15 sn v sky130_fd_pr__pfet_01v8 ad=0.5 pd=2 as=0.5 ps=2 w=1 l=2
X7 g nb1 na1 g sky130_fd_pr__nfet_01v8 ad=0.441 pd=1.89 as=0.609 ps=3.13 w=0.84 l=0.55
X8 nb0 nb14 g g sky130_fd_pr__nfet_01v8 ad=3.045 pd=9.85 as=2.205 ps=5.25 w=4.2 l=0.55
X9 g na0 a_16514_20410# g sky130_fd_pr__nfet_01v8_lvt ad=4.2 pd=6.1 as=3.02 ps=9.51 w=4 l=0.15
X10 v a_8706_8456# g4 v sky130_fd_pr__pfet_01v8 ad=0.6972 pd=3.34 as=0.6972 ps=3.34 w=0.84 l=0.15
X11 rn na11 na12 v sky130_fd_pr__pfet_01v8_lvt ad=4.41 pd=9.45 as=6.09 ps=18.25 w=8.4 l=0.55
X12 rp pb0 pa0 v sky130_fd_pr__pfet_01v8_lvt ad=0.882 pd=2.73 as=1.218 ps=4.81 w=1.68 l=0.55
X13 v a_10939_20410# a_10939_23358# v sky130_fd_pr__pfet_01v8 ad=0.3171 pd=2.35 as=0.3171 ps=2.35 w=0.42 l=2.4
X14 v g20 sp v sky130_fd_pr__pfet_01v8 ad=0.5 pd=2 as=0.5 ps=2 w=1 l=2
X15 sn g20 v v sky130_fd_pr__pfet_01v8 ad=0.5 pd=2 as=0.5 ps=2 w=1 l=2
X16 rp pb7 pa7 v sky130_fd_pr__pfet_01v8_lvt ad=0.882 pd=2.73 as=1.218 ps=4.81 w=1.68 l=0.55
X17 g a_7984_20410# p8 g sky130_fd_pr__nfet_01v8 ad=0.441 pd=2.52 as=0.3171 ps=2.35 w=0.42 l=0.15
X18 pb1 pa1 g g sky130_fd_pr__nfet_01v8 ad=0.609 pd=3.13 as=0.441 ps=1.89 w=0.84 l=0.55
X19 g na5 na6 g sky130_fd_pr__nfet_01v8 ad=2.205 pd=5.25 as=3.045 ps=9.85 w=4.2 l=0.55
X20 g a_3059_20410# p3 g sky130_fd_pr__nfet_01v8 ad=0.441 pd=2.52 as=0.3171 ps=2.35 w=0.42 l=0.15
X21 g a_21439_20410# n5 g sky130_fd_pr__nfet_01v8 ad=0.441 pd=2.52 as=0.3171 ps=2.35 w=0.42 l=0.15
X22 v a_17499_23358# a_17499_20410# v sky130_fd_pr__pfet_01v8 ad=0.3171 pd=2.35 as=0.3171 ps=2.35 w=0.42 l=2.4
X23 a_26995_21538# a_26364_23358# v v sky130_fd_pr__pfet_01v8 ad=0.6342 pd=3.19 as=0.882 ps=2.94 w=0.84 l=0.15
X24 pb13 pb12 rp v sky130_fd_pr__pfet_01v8_lvt ad=6.09 pd=18.25 as=4.41 ps=9.45 w=8.4 l=0.55
X25 pb14 pa14 g g sky130_fd_pr__nfet_01v8 ad=0.609 pd=3.13 as=0.441 ps=1.89 w=0.84 l=0.55
X26 a_11570_21538# a_10939_23358# g g sky130_fd_pr__nfet_01v8 ad=0.3171 pd=2.35 as=0.441 ps=2.52 w=0.42 l=0.15
X27 rp pb13 pa13 v sky130_fd_pr__pfet_01v8_lvt ad=0.882 pd=2.73 as=1.218 ps=4.81 w=1.68 l=0.55
X28 g nb3 sky130_fd_pr__cap_mim_m3_1 l=4.5 w=4.5
X29 rp pb4 pa4 v sky130_fd_pr__pfet_01v8_lvt ad=0.882 pd=2.73 as=1.218 ps=4.81 w=1.68 l=0.55
X30 v a_2074_20410# a_2074_23358# v sky130_fd_pr__pfet_01v8 ad=0.3171 pd=2.35 as=0.3171 ps=2.35 w=0.42 l=2.4
X31 nb5 nb4 g g sky130_fd_pr__nfet_01v8 ad=3.045 pd=9.85 as=2.205 ps=5.25 w=4.2 l=0.55
X32 sn vb v v sky130_fd_pr__pfet_01v8 ad=0.5 pd=2 as=0.73 ps=3.46 w=1 l=2
X33 sp g4 v v sky130_fd_pr__pfet_01v8 ad=0.5 pd=2 as=0.5 ps=2 w=1 l=2
X34 g na0 sky130_fd_pr__cap_mim_m3_1 l=4.5 w=4.5
X35 g pa7 pa8 g sky130_fd_pr__nfet_01v8 ad=2.205 pd=5.25 as=3.045 ps=9.85 w=4.2 l=0.55
X36 pb5 pa5 g g sky130_fd_pr__nfet_01v8 ad=0.609 pd=3.13 as=0.441 ps=1.89 w=0.84 l=0.55
X37 v g15 sn v sky130_fd_pr__pfet_01v8 ad=0.5 pd=2 as=0.5 ps=2 w=1 l=2
X38 vb a_12948_8456# g15 g sky130_fd_pr__nfet_01v8 ad=0.3486 pd=2.5 as=0.3486 ps=2.5 w=0.42 l=0.15
X39 g a_6999_20410# p7 g sky130_fd_pr__nfet_01v8 ad=0.441 pd=2.52 as=0.3171 ps=2.35 w=0.42 l=0.15
X40 v g20 sp v sky130_fd_pr__pfet_01v8 ad=0.5 pd=2 as=0.5 ps=2 w=1 l=2
X41 a_7630_21538# a_6999_23358# v v sky130_fd_pr__pfet_01v8 ad=0.6342 pd=3.19 as=0.882 ps=2.94 w=0.84 l=0.15
X42 g pa10 a_9954_20410# g sky130_fd_pr__nfet_01v8_lvt ad=4.2 pd=6.1 as=3.02 ps=9.51 w=4 l=0.15
X43 vb a_9918_8456# g20 g sky130_fd_pr__nfet_01v8 ad=0.3486 pd=2.5 as=0.3486 ps=2.5 w=0.42 l=0.15
X44 a_26010_21538# a_25379_23358# v v sky130_fd_pr__pfet_01v8 ad=0.6342 pd=3.19 as=0.882 ps=2.94 w=0.84 l=0.15
X45 v a_30304_20410# n14 v sky130_fd_pr__pfet_01v8 ad=0.882 pd=2.94 as=0.6342 ps=3.19 w=0.84 l=0.15
X46 rp pb10 pa10 v sky130_fd_pr__pfet_01v8_lvt ad=0.882 pd=2.73 as=1.218 ps=4.81 w=1.68 l=0.55
X47 rn nb8 na8 v sky130_fd_pr__pfet_01v8_lvt ad=0.882 pd=2.73 as=1.218 ps=4.81 w=1.68 l=0.55
X48 v a_6014_20410# a_6014_23358# v sky130_fd_pr__pfet_01v8 ad=0.3171 pd=2.35 as=0.3171 ps=2.35 w=0.42 l=2.4
X49 nb9 na9 g g sky130_fd_pr__nfet_01v8 ad=0.609 pd=3.13 as=0.441 ps=1.89 w=0.84 l=0.55
X50 v a_1089_20410# a_1089_23358# v sky130_fd_pr__pfet_01v8 ad=0.3171 pd=2.35 as=0.3171 ps=2.35 w=0.42 l=2.4
X51 g a_27349_20410# n11 g sky130_fd_pr__nfet_01v8 ad=0.441 pd=2.52 as=0.3171 ps=2.35 w=0.42 l=0.15
X52 rn na2 na3 v sky130_fd_pr__pfet_01v8_lvt ad=4.41 pd=9.45 as=6.09 ps=18.25 w=8.4 l=0.55
X53 nb4 nb3 rn v sky130_fd_pr__pfet_01v8_lvt ad=6.09 pd=18.25 as=4.41 ps=9.45 w=8.4 l=0.55
X54 g pb8 sky130_fd_pr__cap_mim_m3_1 l=4.5 w=4.5
X55 g nb12 sky130_fd_pr__cap_mim_m3_1 l=4.5 w=4.5
X56 g pa14 a_13894_20410# g sky130_fd_pr__nfet_01v8_lvt ad=4.2 pd=6.1 as=3.02 ps=9.51 w=4 l=0.15
X57 rn vinp sn sn sky130_fd_pr__pfet_01v8_lvt ad=5.7 pd=13.9 as=6 ps=8 w=6 l=1
X58 nb14 nb13 g g sky130_fd_pr__nfet_01v8 ad=3.045 pd=9.85 as=2.205 ps=5.25 w=4.2 l=0.55
X59 g v a_30400_15860# g sky130_fd_pr__nfet_01v8 ad=2.205 pd=5.25 as=3.045 ps=9.85 w=4.2 l=0.55
X60 sn g15 v v sky130_fd_pr__pfet_01v8 ad=0.5 pd=2 as=0.73 ps=3.46 w=1 l=2
X61 a_19115_21538# a_18484_23358# v v sky130_fd_pr__pfet_01v8 ad=0.6342 pd=3.19 as=0.882 ps=2.94 w=0.84 l=0.15
X62 sp g15 v v sky130_fd_pr__pfet_01v8 ad=0.5 pd=2 as=0.5 ps=2 w=1 l=2
X63 pb3 pb2 rp v sky130_fd_pr__pfet_01v8_lvt ad=6.09 pd=18.25 as=4.41 ps=9.45 w=8.4 l=0.55
X64 g pb14 sky130_fd_pr__cap_mim_m3_1 l=4.5 w=4.5
X65 v g20 sn v sky130_fd_pr__pfet_01v8 ad=0.5 pd=2 as=0.5 ps=2 w=1 l=2
X66 a_6645_21538# a_6014_23358# g g sky130_fd_pr__nfet_01v8 ad=0.3171 pd=2.35 as=0.441 ps=2.52 w=0.42 l=0.15
X67 g a_2330_8340# a_2330_8340# g sky130_fd_pr__nfet_01v8 ad=1.66 pd=5.66 as=1.66 ps=5.66 w=2 l=2
X68 v a_16514_20410# n0 v sky130_fd_pr__pfet_01v8 ad=0.882 pd=2.94 as=0.6342 ps=3.19 w=0.84 l=0.15
X69 rn nb12 na12 v sky130_fd_pr__pfet_01v8_lvt ad=0.882 pd=2.73 as=1.218 ps=4.81 w=1.68 l=0.55
X70 v a_26364_20410# a_26364_23358# v sky130_fd_pr__pfet_01v8 ad=0.3171 pd=2.35 as=0.3171 ps=2.35 w=0.42 l=2.4
X71 a_25025_21538# a_24394_23358# g g sky130_fd_pr__nfet_01v8 ad=0.3171 pd=2.35 as=0.441 ps=2.52 w=0.42 l=0.15
X72 nb6 na6 g g sky130_fd_pr__nfet_01v8 ad=0.609 pd=3.13 as=0.441 ps=1.89 w=0.84 l=0.55
X73 nb13 na13 g g sky130_fd_pr__nfet_01v8 ad=0.609 pd=3.13 as=0.441 ps=1.89 w=0.84 l=0.55
X74 v a_5029_20410# a_5029_23358# v sky130_fd_pr__pfet_01v8 ad=0.3171 pd=2.35 as=0.3171 ps=2.35 w=0.42 l=2.4
X75 rp pa10 pa11 v sky130_fd_pr__pfet_01v8_lvt ad=4.41 pd=9.45 as=6.09 ps=18.25 w=8.4 l=0.55
X76 g pb3 sky130_fd_pr__cap_mim_m3_1 l=4.5 w=4.5
X77 v a_20454_23358# a_20454_20410# v sky130_fd_pr__pfet_01v8 ad=0.3171 pd=2.35 as=0.3171 ps=2.35 w=0.42 l=2.4
X78 g nb7 sky130_fd_pr__cap_mim_m3_1 l=4.5 w=4.5
X79 v a_4044_23358# a_4044_20410# v sky130_fd_pr__pfet_01v8 ad=0.3171 pd=2.35 as=0.3171 ps=2.35 w=0.42 l=2.4
X80 a_20454_23358# nb4 g g sky130_fd_pr__nfet_01v8_lvt ad=3.02 pd=9.51 as=4.2 ps=6.1 w=4 l=0.15
X81 g na9 sky130_fd_pr__cap_mim_m3_1 l=4.5 w=4.5
X82 g a_6888_8456# a_9918_8456# g sky130_fd_pr__nfet_01v8 ad=0.3486 pd=2.5 as=0.3486 ps=2.5 w=0.42 l=0.15
X83 g pa13 a_12909_20410# g sky130_fd_pr__nfet_01v8_lvt ad=4.2 pd=6.1 as=3.02 ps=9.51 w=4 l=0.15
X84 g na0 na1 g sky130_fd_pr__nfet_01v8 ad=2.205 pd=5.25 as=3.045 ps=9.85 w=4.2 l=0.55
X85 pb7 pb6 rp v sky130_fd_pr__pfet_01v8_lvt ad=6.09 pd=18.25 as=4.41 ps=9.45 w=8.4 l=0.55
X86 g pb3 pa3 g sky130_fd_pr__nfet_01v8 ad=0.441 pd=1.89 as=0.609 ps=3.13 w=0.84 l=0.55
X87 pb8 pa8 g g sky130_fd_pr__nfet_01v8 ad=0.609 pd=3.13 as=0.441 ps=1.89 w=0.84 l=0.55
X88 rn na13 na14 v sky130_fd_pr__pfet_01v8_lvt ad=4.41 pd=9.45 as=6.09 ps=18.25 w=8.4 l=0.55
X89 g pa11 sky130_fd_pr__cap_mim_m3_1 l=4.5 w=4.5
X90 a_5660_21538# a_5029_23358# g g sky130_fd_pr__nfet_01v8 ad=0.3171 pd=2.35 as=0.441 ps=2.52 w=0.42 l=0.15
X91 sn g20 v v sky130_fd_pr__pfet_01v8 ad=0.5 pd=2 as=0.73 ps=3.46 w=1 l=2
X92 v a_25379_20410# a_25379_23358# v sky130_fd_pr__pfet_01v8 ad=0.3171 pd=2.35 as=0.3171 ps=2.35 w=0.42 l=2.4
X93 sp g20 v v sky130_fd_pr__pfet_01v8 ad=0.5 pd=2 as=0.5 ps=2 w=1 l=2
X94 v g20 sn v sky130_fd_pr__pfet_01v8 ad=0.5 pd=2 as=0.5 ps=2 w=1 l=2
X95 v a_12342_8456# a_12948_8456# v sky130_fd_pr__pfet_01v8 ad=0.6972 pd=3.34 as=0.6972 ps=3.34 w=0.84 l=0.15
X96 v a_24394_23358# a_24394_20410# v sky130_fd_pr__pfet_01v8 ad=0.3171 pd=2.35 as=0.3171 ps=2.35 w=0.42 l=2.4
X97 g nb4 sky130_fd_pr__cap_mim_m3_1 l=4.5 w=4.5
X98 v a_6282_8456# a_9312_8456# v sky130_fd_pr__pfet_01v8 ad=0.6972 pd=3.34 as=0.6972 ps=3.34 w=0.84 l=0.15
X99 v a_9954_20410# p10 v sky130_fd_pr__pfet_01v8 ad=0.882 pd=2.94 as=0.6342 ps=3.19 w=0.84 l=0.15
X100 a_19469_23358# nb3 g g sky130_fd_pr__nfet_01v8_lvt ad=3.02 pd=9.51 as=4.2 ps=6.1 w=4 l=0.15
X101 nb11 nb10 rn v sky130_fd_pr__pfet_01v8_lvt ad=6.09 pd=18.25 as=4.41 ps=9.45 w=8.4 l=0.55
X102 g nb7 na7 g sky130_fd_pr__nfet_01v8 ad=0.441 pd=1.89 as=0.609 ps=3.13 w=0.84 l=0.55
X103 g b1 a_8100_8456# g sky130_fd_pr__nfet_01v8 ad=0.3486 pd=2.5 as=0.3486 ps=2.5 w=0.42 l=0.15
X104 g na6 a_22424_20410# g sky130_fd_pr__nfet_01v8_lvt ad=4.2 pd=6.1 as=3.02 ps=9.51 w=4 l=0.15
X105 g na10 sky130_fd_pr__cap_mim_m3_1 l=4.5 w=4.5
X106 sp vinn rp sp sky130_fd_pr__pfet_01v8_lvt ad=6 pd=8 as=5.7 ps=13.9 w=6 l=1
X107 v a_104_23358# a_104_20410# v sky130_fd_pr__pfet_01v8 ad=0.3171 pd=2.35 as=0.3171 ps=2.35 w=0.42 l=2.4
X108 a_9600_21538# a_8969_23358# g g sky130_fd_pr__nfet_01v8 ad=0.3171 pd=2.35 as=0.441 ps=2.52 w=0.42 l=0.15
X109 rn na14 na0 v sky130_fd_pr__pfet_01v8_lvt ad=4.41 pd=9.45 as=6.09 ps=18.25 w=8.4 l=0.55
X110 v a_29319_20410# a_29319_23358# v sky130_fd_pr__pfet_01v8 ad=0.3171 pd=2.35 as=0.3171 ps=2.35 w=0.42 l=2.4
X111 v g4 sn v sky130_fd_pr__pfet_01v8 ad=0.5 pd=2 as=0.5 ps=2 w=1 l=2
X112 a_11924_23358# pb12 g g sky130_fd_pr__nfet_01v8_lvt ad=3.02 pd=9.51 as=4.2 ps=6.1 w=4 l=0.15
X113 v a_28334_23358# a_28334_20410# v sky130_fd_pr__pfet_01v8 ad=0.3171 pd=2.35 as=0.3171 ps=2.35 w=0.42 l=2.4
X114 pb13 pa13 rp v sky130_fd_pr__pfet_01v8_lvt ad=1.218 pd=4.81 as=0.882 ps=2.73 w=1.68 l=0.55
X115 rs a_2330_8340# vb g sky130_fd_pr__nfet_01v8 ad=6.64 pd=17.66 as=6.64 ps=17.66 w=8 l=2
X116 nb2 na2 rn v sky130_fd_pr__pfet_01v8_lvt ad=1.218 pd=4.81 as=0.882 ps=2.73 w=1.68 l=0.55
X117 v a_23409_23358# a_23409_20410# v sky130_fd_pr__pfet_01v8 ad=0.3171 pd=2.35 as=0.3171 ps=2.35 w=0.42 l=2.4
X118 a_10524_8456# b1 a_11130_8456# v sky130_fd_pr__pfet_01v8 ad=0.6972 pd=3.34 as=0.6972 ps=3.34 w=0.84 l=0.15
X119 pb10 pb9 g g sky130_fd_pr__nfet_01v8 ad=3.045 pd=9.85 as=2.205 ps=5.25 w=4.2 l=0.55
X120 sn g20 v v sky130_fd_pr__pfet_01v8 ad=0.5 pd=2 as=0.73 ps=3.46 w=1 l=2
X121 g nb4 na4 g sky130_fd_pr__nfet_01v8 ad=0.441 pd=1.89 as=0.609 ps=3.13 w=0.84 l=0.55
X122 v a_13894_20410# p14 v sky130_fd_pr__pfet_01v8 ad=0.882 pd=2.94 as=0.6342 ps=3.19 w=0.84 l=0.15
X123 sp g20 v v sky130_fd_pr__pfet_01v8 ad=0.5 pd=2 as=0.5 ps=2 w=1 l=2
X124 g pb9 pa9 g sky130_fd_pr__nfet_01v8 ad=0.441 pd=1.89 as=0.609 ps=3.13 w=0.84 l=0.55
X125 g pa8 a_7984_20410# g sky130_fd_pr__nfet_01v8_lvt ad=4.2 pd=6.1 as=3.02 ps=9.51 w=4 l=0.15
X126 g nb11 na11 g sky130_fd_pr__nfet_01v8 ad=0.441 pd=1.89 as=0.609 ps=3.13 w=0.84 l=0.55
X127 g pa3 a_3059_20410# g sky130_fd_pr__nfet_01v8_lvt ad=4.2 pd=6.1 as=3.02 ps=9.51 w=4 l=0.15
X128 a_29950_21538# a_29319_23358# g g sky130_fd_pr__nfet_01v8 ad=0.3171 pd=2.35 as=0.441 ps=2.52 w=0.42 l=0.15
X129 g na5 a_21439_20410# g sky130_fd_pr__nfet_01v8_lvt ad=4.2 pd=6.1 as=3.02 ps=9.51 w=4 l=0.15
X130 v a_11130_8456# a_11736_8456# v sky130_fd_pr__pfet_01v8 ad=0.6972 pd=3.34 as=0.6972 ps=3.34 w=0.84 l=0.15
X131 v a_6282_8456# a_7494_8456# v sky130_fd_pr__pfet_01v8 ad=0.6972 pd=3.34 as=0.6972 ps=3.34 w=0.84 l=0.15
X132 g nb0 sky130_fd_pr__cap_mim_m3_1 l=4.5 w=4.5
X133 nb9 nb8 g g sky130_fd_pr__nfet_01v8 ad=3.045 pd=9.85 as=2.205 ps=5.25 w=4.2 l=0.55
X134 pb10 pa10 rp v sky130_fd_pr__pfet_01v8_lvt ad=1.218 pd=4.81 as=0.882 ps=2.73 w=1.68 l=0.55
X135 a_10939_23358# pb11 g g sky130_fd_pr__nfet_01v8_lvt ad=3.02 pd=9.51 as=4.2 ps=6.1 w=4 l=0.15
X136 v a_8969_23358# a_8969_20410# v sky130_fd_pr__pfet_01v8 ad=0.3171 pd=2.35 as=0.3171 ps=2.35 w=0.42 l=2.4
X137 rp pa4 pa5 v sky130_fd_pr__pfet_01v8_lvt ad=4.41 pd=9.45 as=6.09 ps=18.25 w=8.4 l=0.55
X138 g a_14565_15860# a_13990_15860# g sky130_fd_pr__nfet_01v8 ad=0.441 pd=1.89 as=0.609 ps=3.13 w=0.84 l=0.55
X139 g v a_13990_15860# g sky130_fd_pr__nfet_01v8 ad=2.205 pd=5.25 as=3.045 ps=9.85 w=4.2 l=0.55
X140 pb14 pb13 g g sky130_fd_pr__nfet_01v8 ad=3.045 pd=9.85 as=2.205 ps=5.25 w=4.2 l=0.55
X141 g pb6 pa6 g sky130_fd_pr__nfet_01v8 ad=0.441 pd=1.89 as=0.609 ps=3.13 w=0.84 l=0.55
X142 a_21085_21538# a_20454_23358# v v sky130_fd_pr__pfet_01v8 ad=0.6342 pd=3.19 as=0.882 ps=2.94 w=0.84 l=0.15
X143 v g15 sn v sky130_fd_pr__pfet_01v8 ad=0.5 pd=2 as=0.5 ps=2 w=1 l=2
X144 v a_12909_20410# p13 v sky130_fd_pr__pfet_01v8 ad=0.882 pd=2.94 as=0.6342 ps=3.19 w=0.84 l=0.15
X145 pb1 pb0 g g sky130_fd_pr__nfet_01v8 ad=3.045 pd=9.85 as=2.205 ps=5.25 w=4.2 l=0.55
X146 g pa7 a_6999_20410# g sky130_fd_pr__nfet_01v8_lvt ad=4.2 pd=6.1 as=3.02 ps=9.51 w=4 l=0.15
X147 nb3 nb2 rn v sky130_fd_pr__pfet_01v8_lvt ad=6.09 pd=18.25 as=4.41 ps=9.45 w=8.4 l=0.55
X148 rn nb14 na14 v sky130_fd_pr__pfet_01v8_lvt ad=0.882 pd=2.73 as=1.218 ps=4.81 w=1.68 l=0.55
X149 a_30975_15860# a_30400_15860# g g sky130_fd_pr__nfet_01v8 ad=0.609 pd=3.13 as=0.441 ps=1.89 w=0.84 l=0.55
X150 a_18130_21538# a_17499_23358# g g sky130_fd_pr__nfet_01v8 ad=0.3171 pd=2.35 as=0.441 ps=2.52 w=0.42 l=0.15
X151 nb13 nb12 g g sky130_fd_pr__nfet_01v8 ad=3.045 pd=9.85 as=2.205 ps=5.25 w=4.2 l=0.55
X152 rn nb3 na3 v sky130_fd_pr__pfet_01v8_lvt ad=0.882 pd=2.73 as=1.218 ps=4.81 w=1.68 l=0.55
X153 g na14 sky130_fd_pr__cap_mim_m3_1 l=4.5 w=4.5
X154 g pb12 pa12 g sky130_fd_pr__nfet_01v8 ad=0.441 pd=1.89 as=0.609 ps=3.13 w=0.84 l=0.55
X155 rn na8 na9 v sky130_fd_pr__pfet_01v8_lvt ad=4.41 pd=9.45 as=6.09 ps=18.25 w=8.4 l=0.55
X156 nb8 nb7 rn v sky130_fd_pr__pfet_01v8_lvt ad=6.09 pd=18.25 as=4.41 ps=9.45 w=8.4 l=0.55
X157 pb3 pa3 rp v sky130_fd_pr__pfet_01v8_lvt ad=1.218 pd=4.81 as=0.882 ps=2.73 w=1.68 l=0.55
X158 g pa5 sky130_fd_pr__cap_mim_m3_1 l=4.5 w=4.5
X159 vb a_13554_8456# g20 v sky130_fd_pr__pfet_01v8 ad=0.6972 pd=3.34 as=0.6972 ps=3.34 w=0.84 l=0.15
X160 nb5 na5 rn v sky130_fd_pr__pfet_01v8_lvt ad=1.218 pd=4.81 as=0.882 ps=2.73 w=1.68 l=0.55
X161 sp g15 v v sky130_fd_pr__pfet_01v8 ad=0.5 pd=2 as=0.5 ps=2 w=1 l=2
X162 rp pa13 pa14 v sky130_fd_pr__pfet_01v8_lvt ad=4.41 pd=9.45 as=6.09 ps=18.25 w=8.4 l=0.55
X163 a_20100_21538# a_19469_23358# v v sky130_fd_pr__pfet_01v8 ad=0.6342 pd=3.19 as=0.882 ps=2.94 w=0.84 l=0.15
X164 g na11 a_27349_20410# g sky130_fd_pr__nfet_01v8_lvt ad=4.2 pd=6.1 as=3.02 ps=9.51 w=4 l=0.15
X165 v a_22424_20410# n6 v sky130_fd_pr__pfet_01v8 ad=0.882 pd=2.94 as=0.6342 ps=3.19 w=0.84 l=0.15
X166 g a_11924_20410# p12 g sky130_fd_pr__nfet_01v8 ad=0.441 pd=2.52 as=0.3171 ps=2.35 w=0.42 l=0.15
X167 rp pa0 pa1 v sky130_fd_pr__pfet_01v8_lvt ad=4.41 pd=9.45 as=6.09 ps=18.25 w=8.4 l=0.55
X168 rn nb0 na0 v sky130_fd_pr__pfet_01v8_lvt ad=0.882 pd=2.73 as=1.218 ps=4.81 w=1.68 l=0.55
X169 v g20 sn v sky130_fd_pr__pfet_01v8 ad=0.5 pd=2 as=0.5 ps=2 w=1 l=2
X170 pb0 pb14 rp v sky130_fd_pr__pfet_01v8_lvt ad=6.09 pd=18.25 as=4.41 ps=9.45 w=8.4 l=0.55
X171 nb1 na1 g g sky130_fd_pr__nfet_01v8 ad=0.609 pd=3.13 as=0.441 ps=1.89 w=0.84 l=0.55
X172 nb1 nb0 g g sky130_fd_pr__nfet_01v8 ad=3.045 pd=9.85 as=2.205 ps=5.25 w=4.2 l=0.55
X173 a_12555_21538# a_11924_23358# v v sky130_fd_pr__pfet_01v8 ad=0.6342 pd=3.19 as=0.882 ps=2.94 w=0.84 l=0.15
X174 g a_19469_20410# n3 g sky130_fd_pr__nfet_01v8 ad=0.441 pd=2.52 as=0.3171 ps=2.35 w=0.42 l=0.15
X175 a_6014_23358# pb6 g g sky130_fd_pr__nfet_01v8_lvt ad=3.02 pd=9.51 as=4.2 ps=6.1 w=4 l=0.15
X176 rn na12 na13 v sky130_fd_pr__pfet_01v8_lvt ad=4.41 pd=9.45 as=6.09 ps=18.25 w=8.4 l=0.55
X177 nb12 nb11 rn v sky130_fd_pr__pfet_01v8_lvt ad=6.09 pd=18.25 as=4.41 ps=9.45 w=8.4 l=0.55
X178 pb0 pa0 rp v sky130_fd_pr__pfet_01v8_lvt ad=1.218 pd=4.81 as=0.882 ps=2.73 w=1.68 l=0.55
X179 a_24394_23358# nb8 g g sky130_fd_pr__nfet_01v8_lvt ad=3.02 pd=9.51 as=4.2 ps=6.1 w=4 l=0.15
X180 pb7 pa7 rp v sky130_fd_pr__pfet_01v8_lvt ad=1.218 pd=4.81 as=0.882 ps=2.73 w=1.68 l=0.55
X181 g pb9 sky130_fd_pr__cap_mim_m3_1 l=4.5 w=4.5
X182 pb4 pb3 g g sky130_fd_pr__nfet_01v8 ad=3.045 pd=9.85 as=2.205 ps=5.25 w=4.2 l=0.55
X183 g nb13 sky130_fd_pr__cap_mim_m3_1 l=4.5 w=4.5
X184 g na6 na7 g sky130_fd_pr__nfet_01v8 ad=2.205 pd=5.25 as=3.045 ps=9.85 w=4.2 l=0.55
X185 nb6 nb5 g g sky130_fd_pr__nfet_01v8 ad=3.045 pd=9.85 as=2.205 ps=5.25 w=4.2 l=0.55
X186 v a_7984_20410# p8 v sky130_fd_pr__pfet_01v8 ad=0.882 pd=2.94 as=0.6342 ps=3.19 w=0.84 l=0.15
X187 g pa6 sky130_fd_pr__cap_mim_m3_1 l=4.5 w=4.5
X188 v a_3059_20410# p3 v sky130_fd_pr__pfet_01v8 ad=0.882 pd=2.94 as=0.6342 ps=3.19 w=0.84 l=0.15
X189 v vb a_2330_8340# v sky130_fd_pr__pfet_01v8 ad=1.66 pd=5.66 as=1.66 ps=5.66 w=2 l=2
X190 v a_21439_20410# n5 v sky130_fd_pr__pfet_01v8 ad=0.882 pd=2.94 as=0.6342 ps=3.19 w=0.84 l=0.15
X191 g a_14565_15860# sky130_fd_pr__cap_mim_m3_1 l=4.5 w=4.5
X192 g pa11 pa12 g sky130_fd_pr__nfet_01v8 ad=2.205 pd=5.25 as=3.045 ps=9.85 w=4.2 l=0.55
X193 v a_18484_20410# a_18484_23358# v sky130_fd_pr__pfet_01v8 ad=0.3171 pd=2.35 as=0.3171 ps=2.35 w=0.42 l=2.4
X194 g a_10939_20410# p11 g sky130_fd_pr__nfet_01v8 ad=0.441 pd=2.52 as=0.3171 ps=2.35 w=0.42 l=0.15
X195 g pa12 sky130_fd_pr__cap_mim_m3_1 l=4.5 w=4.5
X196 sp g15 v v sky130_fd_pr__pfet_01v8 ad=0.5 pd=2 as=0.5 ps=2 w=1 l=2
X197 v a_30304_23358# a_30304_20410# v sky130_fd_pr__pfet_01v8 ad=0.3171 pd=2.35 as=0.3171 ps=2.35 w=0.42 l=2.4
X198 sn g4 v v sky130_fd_pr__pfet_01v8 ad=0.5 pd=2 as=0.5 ps=2 w=1 l=2
X199 a_11570_21538# a_10939_23358# v v sky130_fd_pr__pfet_01v8 ad=0.6342 pd=3.19 as=0.882 ps=2.94 w=0.84 l=0.15
X200 pb4 pa4 rp v sky130_fd_pr__pfet_01v8_lvt ad=1.218 pd=4.81 as=0.882 ps=2.73 w=1.68 l=0.55
X201 nb11 na11 rn v sky130_fd_pr__pfet_01v8_lvt ad=1.218 pd=4.81 as=0.882 ps=2.73 w=1.68 l=0.55
X202 a_5029_23358# pb5 g g sky130_fd_pr__nfet_01v8_lvt ad=3.02 pd=9.51 as=4.2 ps=6.1 w=4 l=0.15
X203 nb0 nb14 rn v sky130_fd_pr__pfet_01v8_lvt ad=6.09 pd=18.25 as=4.41 ps=9.45 w=8.4 l=0.55
X204 v g20 sn v sky130_fd_pr__pfet_01v8 ad=0.5 pd=2 as=0.5 ps=2 w=1 l=2
X205 pb8 pb7 g g sky130_fd_pr__nfet_01v8 ad=3.045 pd=9.85 as=2.205 ps=5.25 w=4.2 l=0.55
X206 g pa8 pa9 g sky130_fd_pr__nfet_01v8 ad=2.205 pd=5.25 as=3.045 ps=9.85 w=4.2 l=0.55
X207 g nb10 sky130_fd_pr__cap_mim_m3_1 l=4.5 w=4.5
X208 g a_9918_8456# a_13554_8456# g sky130_fd_pr__nfet_01v8 ad=0.3486 pd=2.5 as=0.3486 ps=2.5 w=0.42 l=0.15
X209 v a_6999_20410# p7 v sky130_fd_pr__pfet_01v8 ad=0.882 pd=2.94 as=0.6342 ps=3.19 w=0.84 l=0.15
X210 rn g sky130_fd_pr__cap_mim_m3_1 l=21.8 w=21.8
X211 rn na5 na6 v sky130_fd_pr__pfet_01v8_lvt ad=4.41 pd=9.45 as=6.09 ps=18.25 w=8.4 l=0.55
X212 rp pb1 pa1 v sky130_fd_pr__pfet_01v8_lvt ad=0.882 pd=2.73 as=1.218 ps=4.81 w=1.68 l=0.55
X213 v a_17499_20410# a_17499_23358# v sky130_fd_pr__pfet_01v8 ad=0.3171 pd=2.35 as=0.3171 ps=2.35 w=0.42 l=2.4
X214 g a_2074_20410# p2 g sky130_fd_pr__nfet_01v8 ad=0.441 pd=2.52 as=0.3171 ps=2.35 w=0.42 l=0.15
X215 v b0 a_6282_8456# v sky130_fd_pr__pfet_01v8 ad=0.6972 pd=3.34 as=0.6972 ps=3.34 w=0.84 l=0.15
X216 nb8 na8 rn v sky130_fd_pr__pfet_01v8_lvt ad=1.218 pd=4.81 as=0.882 ps=2.73 w=1.68 l=0.55
X217 v a_16514_23358# a_16514_20410# v sky130_fd_pr__pfet_01v8 ad=0.3171 pd=2.35 as=0.3171 ps=2.35 w=0.42 l=2.4
X218 a_8969_23358# pb9 g g sky130_fd_pr__nfet_01v8_lvt ad=3.02 pd=9.51 as=4.2 ps=6.1 w=4 l=0.15
X219 g nb5 sky130_fd_pr__cap_mim_m3_1 l=4.5 w=4.5
X220 sp g20 v v sky130_fd_pr__pfet_01v8 ad=0.5 pd=2 as=0.5 ps=2 w=1 l=2
X221 a_10585_21538# a_9954_23358# g g sky130_fd_pr__nfet_01v8 ad=0.3171 pd=2.35 as=0.441 ps=2.52 w=0.42 l=0.15
X222 nb5 nb4 rn v sky130_fd_pr__pfet_01v8_lvt ad=6.09 pd=18.25 as=4.41 ps=9.45 w=8.4 l=0.55
X223 v a_27349_20410# n11 v sky130_fd_pr__pfet_01v8 ad=0.882 pd=2.94 as=0.6342 ps=3.19 w=0.84 l=0.15
X224 sn g15 v v sky130_fd_pr__pfet_01v8 ad=0.5 pd=2 as=0.5 ps=2 w=1 l=2
X225 rp pa7 pa8 v sky130_fd_pr__pfet_01v8_lvt ad=4.41 pd=9.45 as=6.09 ps=18.25 w=8.4 l=0.55
X226 a_14565_15860# a_13990_15860# g g sky130_fd_pr__nfet_01v8 ad=0.609 pd=3.13 as=0.441 ps=1.89 w=0.84 l=0.55
X227 a_30975_15860# v g g sky130_fd_pr__nfet_01v8 ad=3.045 pd=9.85 as=2.205 ps=5.25 w=4.2 l=0.55
X228 rp pb5 pa5 v sky130_fd_pr__pfet_01v8_lvt ad=0.882 pd=2.73 as=1.218 ps=4.81 w=1.68 l=0.55
X229 g a_11130_8456# a_12342_8456# g sky130_fd_pr__nfet_01v8 ad=0.3486 pd=2.5 as=0.3486 ps=2.5 w=0.42 l=0.15
X230 g pa1 pa2 g sky130_fd_pr__nfet_01v8 ad=2.205 pd=5.25 as=3.045 ps=9.85 w=4.2 l=0.55
X231 g a_6014_20410# p6 g sky130_fd_pr__nfet_01v8 ad=0.441 pd=2.52 as=0.3171 ps=2.35 w=0.42 l=0.15
X232 g a_1089_20410# p1 g sky130_fd_pr__nfet_01v8 ad=0.441 pd=2.52 as=0.3171 ps=2.35 w=0.42 l=0.15
X233 g na3 na4 g sky130_fd_pr__nfet_01v8 ad=2.205 pd=5.25 as=3.045 ps=9.85 w=4.2 l=0.55
X234 nb12 na12 rn v sky130_fd_pr__pfet_01v8_lvt ad=1.218 pd=4.81 as=0.882 ps=2.73 w=1.68 l=0.55
X235 a_6645_21538# a_6014_23358# v v sky130_fd_pr__pfet_01v8 ad=0.6342 pd=3.19 as=0.882 ps=2.94 w=0.84 l=0.15
X236 a_29319_23358# nb13 g g sky130_fd_pr__nfet_01v8_lvt ad=3.02 pd=9.51 as=4.2 ps=6.1 w=4 l=0.15
X237 g a_9918_8456# a_12342_8456# g sky130_fd_pr__nfet_01v8 ad=0.3486 pd=2.5 as=0.3486 ps=2.5 w=0.42 l=0.15
X238 sp vinn rp sp sky130_fd_pr__pfet_01v8_lvt ad=6 pd=8 as=5.7 ps=13.9 w=6 l=1
X239 a_25025_21538# a_24394_23358# v v sky130_fd_pr__pfet_01v8 ad=0.6342 pd=3.19 as=0.882 ps=2.94 w=0.84 l=0.15
X240 g pa0 sky130_fd_pr__cap_mim_m3_1 l=4.5 w=4.5
X241 a_14525_21538# a_13894_23358# g g sky130_fd_pr__nfet_01v8 ad=0.3171 pd=2.35 as=0.441 ps=2.52 w=0.42 l=0.15
X242 pb12 pa12 g g sky130_fd_pr__nfet_01v8 ad=0.609 pd=3.13 as=0.441 ps=1.89 w=0.84 l=0.55
X243 v g15 sp v sky130_fd_pr__pfet_01v8 ad=0.5 pd=2 as=0.5 ps=2 w=1 l=2
X244 rp vinn sp sp sky130_fd_pr__pfet_01v8_lvt ad=5.7 pd=13.9 as=6 ps=8 w=6 l=1
X245 rp pb11 pa11 v sky130_fd_pr__pfet_01v8_lvt ad=0.882 pd=2.73 as=1.218 ps=4.81 w=1.68 l=0.55
X246 a_24040_21538# a_23409_23358# g g sky130_fd_pr__nfet_01v8 ad=0.3171 pd=2.35 as=0.441 ps=2.52 w=0.42 l=0.15
X247 rp pb2 pa2 v sky130_fd_pr__pfet_01v8_lvt ad=0.882 pd=2.73 as=1.218 ps=4.81 w=1.68 l=0.55
X248 v a_9954_23358# a_9954_20410# v sky130_fd_pr__pfet_01v8 ad=0.3171 pd=2.35 as=0.3171 ps=2.35 w=0.42 l=2.4
X249 rn nb9 na9 v sky130_fd_pr__pfet_01v8_lvt ad=0.882 pd=2.73 as=1.218 ps=4.81 w=1.68 l=0.55
X250 vb a_12342_8456# g15 v sky130_fd_pr__pfet_01v8 ad=0.6972 pd=3.34 as=0.6972 ps=3.34 w=0.84 l=0.15
X251 g a_26364_20410# n10 g sky130_fd_pr__nfet_01v8 ad=0.441 pd=2.52 as=0.3171 ps=2.35 w=0.42 l=0.15
X252 g nb1 sky130_fd_pr__cap_mim_m3_1 l=4.5 w=4.5
X253 g nb14 sky130_fd_pr__cap_mim_m3_1 l=4.5 w=4.5
X254 sp g20 v v sky130_fd_pr__pfet_01v8 ad=0.5 pd=2 as=0.5 ps=2 w=1 l=2
X255 g pa5 pa6 g sky130_fd_pr__nfet_01v8 ad=2.205 pd=5.25 as=3.045 ps=9.85 w=4.2 l=0.55
X256 g v a_30400_15860# v sky130_fd_pr__pfet_01v8_lvt ad=4.41 pd=9.45 as=6.09 ps=18.25 w=8.4 l=0.55
X257 sn g20 v v sky130_fd_pr__pfet_01v8 ad=0.5 pd=2 as=0.5 ps=2 w=1 l=2
X258 nb14 nb13 rn v sky130_fd_pr__pfet_01v8_lvt ad=6.09 pd=18.25 as=4.41 ps=9.45 w=8.4 l=0.55
X259 g a_5029_20410# p5 g sky130_fd_pr__nfet_01v8 ad=0.441 pd=2.52 as=0.3171 ps=2.35 w=0.42 l=0.15
X260 rs refmid g sky130_fd_pr__res_high_po_0p69 l=97.1
X261 g na3 sky130_fd_pr__cap_mim_m3_1 l=4.5 w=4.5
X262 a_5660_21538# a_5029_23358# v v sky130_fd_pr__pfet_01v8 ad=0.6342 pd=3.19 as=0.882 ps=2.94 w=0.84 l=0.15
X263 a_17499_23358# nb1 g g sky130_fd_pr__nfet_01v8_lvt ad=3.02 pd=9.51 as=4.2 ps=6.1 w=4 l=0.15
X264 rp g sky130_fd_pr__cap_mim_m3_1 l=21.8 w=21.8
X265 rn nb6 na6 v sky130_fd_pr__pfet_01v8_lvt ad=0.882 pd=2.73 as=1.218 ps=4.81 w=1.68 l=0.55
X266 v a_20454_20410# a_20454_23358# v sky130_fd_pr__pfet_01v8 ad=0.3171 pd=2.35 as=0.3171 ps=2.35 w=0.42 l=2.4
X267 v a_13894_23358# a_13894_20410# v sky130_fd_pr__pfet_01v8 ad=0.3171 pd=2.35 as=0.3171 ps=2.35 w=0.42 l=2.4
X268 rn nb13 na13 v sky130_fd_pr__pfet_01v8_lvt ad=0.882 pd=2.73 as=1.218 ps=4.81 w=1.68 l=0.55
X269 v a_4044_20410# a_4044_23358# v sky130_fd_pr__pfet_01v8 ad=0.3171 pd=2.35 as=0.3171 ps=2.35 w=0.42 l=2.4
X270 g na9 na10 g sky130_fd_pr__nfet_01v8 ad=2.205 pd=5.25 as=3.045 ps=9.85 w=4.2 l=0.55
X271 nb7 na7 g g sky130_fd_pr__nfet_01v8 ad=0.609 pd=3.13 as=0.441 ps=1.89 w=0.84 l=0.55
X272 g a_25379_20410# n9 g sky130_fd_pr__nfet_01v8 ad=0.441 pd=2.52 as=0.3171 ps=2.35 w=0.42 l=0.15
X273 v g15 sp v sky130_fd_pr__pfet_01v8 ad=0.5 pd=2 as=0.5 ps=2 w=1 l=2
X274 rn na0 na1 v sky130_fd_pr__pfet_01v8_lvt ad=4.41 pd=9.45 as=6.09 ps=18.25 w=8.4 l=0.55
X275 v a_9918_8456# a_13554_8456# v sky130_fd_pr__pfet_01v8 ad=0.6972 pd=3.34 as=0.6972 ps=3.34 w=0.84 l=0.15
X276 g nb2 na2 g sky130_fd_pr__nfet_01v8 ad=0.441 pd=1.89 as=0.609 ps=3.13 w=0.84 l=0.55
X277 a_9600_21538# a_8969_23358# v v sky130_fd_pr__pfet_01v8 ad=0.6342 pd=3.19 as=0.882 ps=2.94 w=0.84 l=0.15
X278 g pa12 a_11924_20410# g sky130_fd_pr__nfet_01v8_lvt ad=4.2 pd=6.1 as=3.02 ps=9.51 w=4 l=0.15
X279 g pb6 sky130_fd_pr__cap_mim_m3_1 l=4.5 w=4.5
X280 sn g20 v v sky130_fd_pr__pfet_01v8 ad=0.5 pd=2 as=0.5 ps=2 w=1 l=2
X281 rp pb8 pa8 v sky130_fd_pr__pfet_01v8_lvt ad=0.882 pd=2.73 as=1.218 ps=4.81 w=1.68 l=0.55
X282 pb11 pb10 g g sky130_fd_pr__nfet_01v8 ad=3.045 pd=9.85 as=2.205 ps=5.25 w=4.2 l=0.55
X283 a_4675_21538# a_4044_23358# g g sky130_fd_pr__nfet_01v8 ad=0.3171 pd=2.35 as=0.441 ps=2.52 w=0.42 l=0.15
X284 g na3 a_19469_20410# g sky130_fd_pr__nfet_01v8_lvt ad=4.2 pd=6.1 as=3.02 ps=9.51 w=4 l=0.15
X285 pb2 pa2 g g sky130_fd_pr__nfet_01v8 ad=0.609 pd=3.13 as=0.441 ps=1.89 w=0.84 l=0.55
X286 g pb12 sky130_fd_pr__cap_mim_m3_1 l=4.5 w=4.5
X287 rn nb10 na10 v sky130_fd_pr__pfet_01v8_lvt ad=0.882 pd=2.73 as=1.218 ps=4.81 w=1.68 l=0.55
X288 v a_24394_20410# a_24394_23358# v sky130_fd_pr__pfet_01v8 ad=0.3171 pd=2.35 as=0.3171 ps=2.35 w=0.42 l=2.4
X289 nb4 na4 g g sky130_fd_pr__nfet_01v8 ad=0.609 pd=3.13 as=0.441 ps=1.89 w=0.84 l=0.55
X290 pb9 pa9 g g sky130_fd_pr__nfet_01v8 ad=0.609 pd=3.13 as=0.441 ps=1.89 w=0.84 l=0.55
X291 v a_12909_23358# a_12909_20410# v sky130_fd_pr__pfet_01v8 ad=0.3171 pd=2.35 as=0.3171 ps=2.35 w=0.42 l=2.4
X292 g a_29319_20410# n13 g sky130_fd_pr__nfet_01v8 ad=0.441 pd=2.52 as=0.3171 ps=2.35 w=0.42 l=0.15
X293 a_29950_21538# a_29319_23358# v v sky130_fd_pr__pfet_01v8 ad=0.6342 pd=3.19 as=0.882 ps=2.94 w=0.84 l=0.15
X294 v g15 sn v sky130_fd_pr__pfet_01v8 ad=0.73 pd=3.46 as=0.5 ps=2 w=1 l=2
X295 rp pb14 pa14 v sky130_fd_pr__pfet_01v8_lvt ad=0.882 pd=2.73 as=1.218 ps=4.81 w=1.68 l=0.55
X296 g pa11 a_10939_20410# g sky130_fd_pr__nfet_01v8_lvt ad=4.2 pd=6.1 as=3.02 ps=9.51 w=4 l=0.15
X297 g pa3 sky130_fd_pr__cap_mim_m3_1 l=4.5 w=4.5
X298 v a_104_20410# a_104_23358# v sky130_fd_pr__pfet_01v8 ad=0.3171 pd=2.35 as=0.3171 ps=2.35 w=0.42 l=2.4
X299 g na7 sky130_fd_pr__cap_mim_m3_1 l=4.5 w=4.5
X300 v g20 sp v sky130_fd_pr__pfet_01v8 ad=0.5 pd=2 as=0.5 ps=2 w=1 l=2
X301 a_14565_15860# v g g sky130_fd_pr__nfet_01v8 ad=3.045 pd=9.85 as=2.205 ps=5.25 w=4.2 l=0.55
X302 a_8615_21538# a_7984_23358# g g sky130_fd_pr__nfet_01v8 ad=0.3171 pd=2.35 as=0.441 ps=2.52 w=0.42 l=0.15
X303 pb6 pa6 g g sky130_fd_pr__nfet_01v8 ad=0.609 pd=3.13 as=0.441 ps=1.89 w=0.84 l=0.55
X304 a_3690_21538# a_3059_23358# g g sky130_fd_pr__nfet_01v8 ad=0.3171 pd=2.35 as=0.441 ps=2.52 w=0.42 l=0.15
X305 v a_28334_20410# a_28334_23358# v sky130_fd_pr__pfet_01v8 ad=0.3171 pd=2.35 as=0.3171 ps=2.35 w=0.42 l=2.4
X306 pb10 pb9 rp v sky130_fd_pr__pfet_01v8_lvt ad=6.09 pd=18.25 as=4.41 ps=9.45 w=8.4 l=0.55
X307 v a_23409_20410# a_23409_23358# v sky130_fd_pr__pfet_01v8 ad=0.3171 pd=2.35 as=0.3171 ps=2.35 w=0.42 l=2.4
X308 nb14 na14 rn v sky130_fd_pr__pfet_01v8_lvt ad=1.218 pd=4.81 as=0.882 ps=2.73 w=1.68 l=0.55
X309 v a_22424_23358# a_22424_20410# v sky130_fd_pr__pfet_01v8 ad=0.3171 pd=2.35 as=0.3171 ps=2.35 w=0.42 l=2.4
X310 sp mid g sky130_fd_pr__res_high_po_0p69 l=80
X311 a_735_21538# a_104_23358# g g sky130_fd_pr__nfet_01v8 ad=0.3171 pd=2.35 as=0.441 ps=2.52 w=0.42 l=0.15
X312 nb3 na3 rn v sky130_fd_pr__pfet_01v8_lvt ad=1.218 pd=4.81 as=0.882 ps=2.73 w=1.68 l=0.55
X313 a_18130_21538# a_17499_23358# v v sky130_fd_pr__pfet_01v8 ad=0.6342 pd=3.19 as=0.882 ps=2.94 w=0.84 l=0.15
X314 g b0 a_11130_8456# g sky130_fd_pr__nfet_01v8 ad=0.3486 pd=2.5 as=0.3486 ps=2.5 w=0.42 l=0.15
X315 g pa2 a_2074_20410# g sky130_fd_pr__nfet_01v8_lvt ad=4.2 pd=6.1 as=3.02 ps=9.51 w=4 l=0.15
X316 nb9 nb8 rn v sky130_fd_pr__pfet_01v8_lvt ad=6.09 pd=18.25 as=4.41 ps=9.45 w=8.4 l=0.55
X317 g nb5 na5 g sky130_fd_pr__nfet_01v8 ad=0.441 pd=1.89 as=0.609 ps=3.13 w=0.84 l=0.55
X318 a_28965_21538# a_28334_23358# g g sky130_fd_pr__nfet_01v8 ad=0.3171 pd=2.35 as=0.441 ps=2.52 w=0.42 l=0.15
X319 sn g15 v v sky130_fd_pr__pfet_01v8 ad=0.5 pd=2 as=0.5 ps=2 w=1 l=2
X320 g nb11 sky130_fd_pr__cap_mim_m3_1 l=4.5 w=4.5
X321 nb10 na10 g g sky130_fd_pr__nfet_01v8 ad=0.609 pd=3.13 as=0.441 ps=1.89 w=0.84 l=0.55
X322 refmid g g sky130_fd_pr__res_high_po_0p69 l=97.1
X323 v a_8969_20410# a_8969_23358# v sky130_fd_pr__pfet_01v8 ad=0.3171 pd=2.35 as=0.3171 ps=2.35 w=0.42 l=2.4
X324 g v a_13990_15860# v sky130_fd_pr__pfet_01v8_lvt ad=4.41 pd=9.45 as=6.09 ps=18.25 w=8.4 l=0.55
X325 v g15 sn v sky130_fd_pr__pfet_01v8 ad=0.73 pd=3.46 as=0.5 ps=2 w=1 l=2
X326 g na8 sky130_fd_pr__cap_mim_m3_1 l=4.5 w=4.5
X327 pb14 pb13 rp v sky130_fd_pr__pfet_01v8_lvt ad=6.09 pd=18.25 as=4.41 ps=9.45 w=8.4 l=0.55
X328 a_9954_23358# pb10 g g sky130_fd_pr__nfet_01v8_lvt ad=3.02 pd=9.51 as=4.2 ps=6.1 w=4 l=0.15
X329 v a_7984_23358# a_7984_20410# v sky130_fd_pr__pfet_01v8 ad=0.3171 pd=2.35 as=0.3171 ps=2.35 w=0.42 l=2.4
X330 v g20 sp v sky130_fd_pr__pfet_01v8 ad=0.5 pd=2 as=0.5 ps=2 w=1 l=2
X331 v a_3059_23358# a_3059_20410# v sky130_fd_pr__pfet_01v8 ad=0.3171 pd=2.35 as=0.3171 ps=2.35 w=0.42 l=2.4
X332 g pb0 sky130_fd_pr__cap_mim_m3_1 l=4.5 w=4.5
X333 pb11 pa11 rp v sky130_fd_pr__pfet_01v8_lvt ad=1.218 pd=4.81 as=0.882 ps=2.73 w=1.68 l=0.55
X334 g pa10 sky130_fd_pr__cap_mim_m3_1 l=4.5 w=4.5
X335 nb0 na0 rn v sky130_fd_pr__pfet_01v8_lvt ad=1.218 pd=4.81 as=0.882 ps=2.73 w=1.68 l=0.55
X336 v a_21439_23358# a_21439_20410# v sky130_fd_pr__pfet_01v8 ad=0.3171 pd=2.35 as=0.3171 ps=2.35 w=0.42 l=2.4
X337 pb1 pb0 rp v sky130_fd_pr__pfet_01v8_lvt ad=6.09 pd=18.25 as=4.41 ps=9.45 w=8.4 l=0.55
X338 g pb0 pa0 g sky130_fd_pr__nfet_01v8 ad=0.441 pd=1.89 as=0.609 ps=3.13 w=0.84 l=0.55
X339 v a_11924_20410# p12 v sky130_fd_pr__pfet_01v8 ad=0.882 pd=2.94 as=0.6342 ps=3.19 w=0.84 l=0.15
X340 g pb7 pa7 g sky130_fd_pr__nfet_01v8 ad=0.441 pd=1.89 as=0.609 ps=3.13 w=0.84 l=0.55
X341 g pa6 a_6014_20410# g sky130_fd_pr__nfet_01v8_lvt ad=4.2 pd=6.1 as=3.02 ps=9.51 w=4 l=0.15
X342 nb13 nb12 rn v sky130_fd_pr__pfet_01v8_lvt ad=6.09 pd=18.25 as=4.41 ps=9.45 w=8.4 l=0.55
X343 g pa1 a_1089_20410# g sky130_fd_pr__nfet_01v8_lvt ad=4.2 pd=6.1 as=3.02 ps=9.51 w=4 l=0.15
X344 v a_19469_20410# n3 v sky130_fd_pr__pfet_01v8 ad=0.882 pd=2.94 as=0.6342 ps=3.19 w=0.84 l=0.15
X345 a_17145_21538# a_16514_23358# g g sky130_fd_pr__nfet_01v8 ad=0.3171 pd=2.35 as=0.441 ps=2.52 w=0.42 l=0.15
X346 a_27980_21538# a_27349_23358# g g sky130_fd_pr__nfet_01v8 ad=0.3171 pd=2.35 as=0.441 ps=2.52 w=0.42 l=0.15
X347 g a_30975_15860# a_30400_15860# v sky130_fd_pr__pfet_01v8_lvt ad=0.882 pd=2.73 as=1.218 ps=4.81 w=1.68 l=0.55
X348 pb5 pb4 g g sky130_fd_pr__nfet_01v8 ad=3.045 pd=9.85 as=2.205 ps=5.25 w=4.2 l=0.55
X349 g a_8100_8456# a_8706_8456# g sky130_fd_pr__nfet_01v8 ad=0.3486 pd=2.5 as=0.3486 ps=2.5 w=0.42 l=0.15
X350 nb7 nb6 g g sky130_fd_pr__nfet_01v8 ad=3.045 pd=9.85 as=2.205 ps=5.25 w=4.2 l=0.55
X351 a_13894_23358# pb14 g g sky130_fd_pr__nfet_01v8_lvt ad=3.02 pd=9.51 as=4.2 ps=6.1 w=4 l=0.15
X352 v g4 sp v sky130_fd_pr__pfet_01v8 ad=0.5 pd=2 as=0.5 ps=2 w=1 l=2
X353 sn g15 v v sky130_fd_pr__pfet_01v8 ad=0.5 pd=2 as=0.5 ps=2 w=1 l=2
X354 v a_6999_23358# a_6999_20410# v sky130_fd_pr__pfet_01v8 ad=0.3171 pd=2.35 as=0.3171 ps=2.35 w=0.42 l=2.4
X355 g a_6282_8456# a_9918_8456# g sky130_fd_pr__nfet_01v8 ad=0.3486 pd=2.5 as=0.3486 ps=2.5 w=0.42 l=0.15
X356 pb12 pb11 g g sky130_fd_pr__nfet_01v8 ad=3.045 pd=9.85 as=2.205 ps=5.25 w=4.2 l=0.55
X357 g pb13 pa13 g sky130_fd_pr__nfet_01v8 ad=0.441 pd=1.89 as=0.609 ps=3.13 w=0.84 l=0.55
X358 g pa12 pa13 g sky130_fd_pr__nfet_01v8 ad=2.205 pd=5.25 as=3.045 ps=9.85 w=4.2 l=0.55
X359 a_23409_23358# nb7 g g sky130_fd_pr__nfet_01v8_lvt ad=3.02 pd=9.51 as=4.2 ps=6.1 w=4 l=0.15
X360 v g20 sn v sky130_fd_pr__pfet_01v8 ad=0.73 pd=3.46 as=0.5 ps=2 w=1 l=2
X361 g pb4 pa4 g sky130_fd_pr__nfet_01v8 ad=0.441 pd=1.89 as=0.609 ps=3.13 w=0.84 l=0.55
X362 g na10 a_26364_20410# g sky130_fd_pr__nfet_01v8_lvt ad=4.2 pd=6.1 as=3.02 ps=9.51 w=4 l=0.15
X363 v a_10939_20410# p11 v sky130_fd_pr__pfet_01v8 ad=0.882 pd=2.94 as=0.6342 ps=3.19 w=0.84 l=0.15
X364 g pa5 a_5029_20410# g sky130_fd_pr__nfet_01v8_lvt ad=4.2 pd=6.1 as=3.02 ps=9.51 w=4 l=0.15
X365 nb1 nb0 rn v sky130_fd_pr__pfet_01v8_lvt ad=6.09 pd=18.25 as=4.41 ps=9.45 w=8.4 l=0.55
X366 a_7494_8456# b1 a_8100_8456# v sky130_fd_pr__pfet_01v8 ad=0.6972 pd=3.34 as=0.6972 ps=3.34 w=0.84 l=0.15
X367 pb9 pb8 g g sky130_fd_pr__nfet_01v8 ad=3.045 pd=9.85 as=2.205 ps=5.25 w=4.2 l=0.55
X368 a_11736_8456# a_9918_8456# a_12342_8456# v sky130_fd_pr__pfet_01v8 ad=0.6972 pd=3.34 as=0.6972 ps=3.34 w=0.84 l=0.15
X369 rn nb1 na1 v sky130_fd_pr__pfet_01v8_lvt ad=0.882 pd=2.73 as=1.218 ps=4.81 w=1.68 l=0.55
X370 g a_18484_20410# n2 g sky130_fd_pr__nfet_01v8 ad=0.441 pd=2.52 as=0.3171 ps=2.35 w=0.42 l=0.15
X371 g a_30975_15860# sky130_fd_pr__cap_mim_m3_1 l=4.5 w=4.5
X372 pb4 pb3 rp v sky130_fd_pr__pfet_01v8_lvt ad=6.09 pd=18.25 as=4.41 ps=9.45 w=8.4 l=0.55
X373 v a_27349_23358# a_27349_20410# v sky130_fd_pr__pfet_01v8 ad=0.3171 pd=2.35 as=0.3171 ps=2.35 w=0.42 l=2.4
X374 rn na6 na7 v sky130_fd_pr__pfet_01v8_lvt ad=4.41 pd=9.45 as=6.09 ps=18.25 w=8.4 l=0.55
X375 v g15 sp v sky130_fd_pr__pfet_01v8 ad=0.73 pd=3.46 as=0.5 ps=2 w=1 l=2
X376 g b1 a_6888_8456# g sky130_fd_pr__nfet_01v8 ad=0.3486 pd=2.5 as=0.3486 ps=2.5 w=0.42 l=0.15
X377 g pb10 pa10 g sky130_fd_pr__nfet_01v8 ad=0.441 pd=1.89 as=0.609 ps=3.13 w=0.84 l=0.55
X378 rp vinn sp sp sky130_fd_pr__pfet_01v8_lvt ad=5.7 pd=13.9 as=6 ps=8 w=6 l=1
X379 nb6 nb5 rn v sky130_fd_pr__pfet_01v8_lvt ad=6.09 pd=18.25 as=4.41 ps=9.45 w=8.4 l=0.55
X380 g nb8 na8 g sky130_fd_pr__nfet_01v8 ad=0.441 pd=1.89 as=0.609 ps=3.13 w=0.84 l=0.55
X381 pb1 pa1 rp v sky130_fd_pr__pfet_01v8_lvt ad=1.218 pd=4.81 as=0.882 ps=2.73 w=1.68 l=0.55
X382 g a_3306_8498# vb g sky130_fd_pr__nfet_01v8 ad=0.415 pd=2.66 as=0.415 ps=2.66 w=0.5 l=1
X383 v g15 sp v sky130_fd_pr__pfet_01v8 ad=0.5 pd=2 as=0.5 ps=2 w=1 l=2
X384 sn g20 v v sky130_fd_pr__pfet_01v8 ad=0.5 pd=2 as=0.5 ps=2 w=1 l=2
X385 rp pa11 pa12 v sky130_fd_pr__pfet_01v8_lvt ad=4.41 pd=9.45 as=6.09 ps=18.25 w=8.4 l=0.55
X386 v a_2074_20410# p2 v sky130_fd_pr__pfet_01v8 ad=0.882 pd=2.94 as=0.6342 ps=3.19 w=0.84 l=0.15
X387 g na9 a_25379_20410# g sky130_fd_pr__nfet_01v8_lvt ad=4.2 pd=6.1 as=3.02 ps=9.51 w=4 l=0.15
X388 v a_30304_20410# a_30304_23358# v sky130_fd_pr__pfet_01v8 ad=0.3171 pd=2.35 as=0.3171 ps=2.35 w=0.42 l=2.4
X389 a_9312_8456# a_6888_8456# a_9918_8456# v sky130_fd_pr__pfet_01v8 ad=0.6972 pd=3.34 as=0.6972 ps=3.34 w=0.84 l=0.15
X390 v g20 sn v sky130_fd_pr__pfet_01v8 ad=0.73 pd=3.46 as=0.5 ps=2 w=1 l=2
X391 vb a_8706_8456# g4 g sky130_fd_pr__nfet_01v8 ad=0.3486 pd=2.5 as=0.3486 ps=2.5 w=0.42 l=0.15
X392 pb14 pa14 rp v sky130_fd_pr__pfet_01v8_lvt ad=1.218 pd=4.81 as=0.882 ps=2.73 w=1.68 l=0.55
X393 g na1 na2 g sky130_fd_pr__nfet_01v8 ad=2.205 pd=5.25 as=3.045 ps=9.85 w=4.2 l=0.55
X394 a_10585_21538# a_9954_23358# v v sky130_fd_pr__pfet_01v8 ad=0.6342 pd=3.19 as=0.882 ps=2.94 w=0.84 l=0.15
X395 rp pa8 pa9 v sky130_fd_pr__pfet_01v8_lvt ad=4.41 pd=9.45 as=6.09 ps=18.25 w=8.4 l=0.55
X396 pb8 pb7 rp v sky130_fd_pr__pfet_01v8_lvt ad=6.09 pd=18.25 as=4.41 ps=9.45 w=8.4 l=0.55
X397 g a_17499_20410# n1 g sky130_fd_pr__nfet_01v8 ad=0.441 pd=2.52 as=0.3171 ps=2.35 w=0.42 l=0.15
X398 a_4044_23358# pb4 g g sky130_fd_pr__nfet_01v8_lvt ad=3.02 pd=9.51 as=4.2 ps=6.1 w=4 l=0.15
X399 g nb12 na12 g sky130_fd_pr__nfet_01v8 ad=0.441 pd=1.89 as=0.609 ps=3.13 w=0.84 l=0.55
X400 pb5 pa5 rp v sky130_fd_pr__pfet_01v8_lvt ad=1.218 pd=4.81 as=0.882 ps=2.73 w=1.68 l=0.55
X401 g pa2 pa3 g sky130_fd_pr__nfet_01v8 ad=2.205 pd=5.25 as=3.045 ps=9.85 w=4.2 l=0.55
X402 pb2 pb1 g g sky130_fd_pr__nfet_01v8 ad=3.045 pd=9.85 as=2.205 ps=5.25 w=4.2 l=0.55
X403 v a_9918_8456# g20 v sky130_fd_pr__pfet_01v8 ad=0.6972 pd=3.34 as=0.6972 ps=3.34 w=0.84 l=0.15
X404 g na4 na5 g sky130_fd_pr__nfet_01v8 ad=2.205 pd=5.25 as=3.045 ps=9.85 w=4.2 l=0.55
X405 a_30935_21538# a_30304_23358# g g sky130_fd_pr__nfet_01v8 ad=0.3171 pd=2.35 as=0.441 ps=2.52 w=0.42 l=0.15
X406 g pb7 sky130_fd_pr__cap_mim_m3_1 l=4.5 w=4.5
X407 v g15 sp v sky130_fd_pr__pfet_01v8 ad=0.73 pd=3.46 as=0.5 ps=2 w=1 l=2
X408 v a_6014_20410# p6 v sky130_fd_pr__pfet_01v8 ad=0.882 pd=2.94 as=0.6342 ps=3.19 w=0.84 l=0.15
X409 g na13 a_29319_20410# g sky130_fd_pr__nfet_01v8_lvt ad=4.2 pd=6.1 as=3.02 ps=9.51 w=4 l=0.15
X410 v a_1089_20410# p1 v sky130_fd_pr__pfet_01v8 ad=0.882 pd=2.94 as=0.6342 ps=3.19 w=0.84 l=0.15
X411 v g15 sn v sky130_fd_pr__pfet_01v8 ad=0.5 pd=2 as=0.5 ps=2 w=1 l=2
X412 g pa4 sky130_fd_pr__cap_mim_m3_1 l=4.5 w=4.5
X413 v a_16514_20410# a_16514_23358# v sky130_fd_pr__pfet_01v8 ad=0.3171 pd=2.35 as=0.3171 ps=2.35 w=0.42 l=2.4
X414 g pa9 sky130_fd_pr__cap_mim_m3_1 l=4.5 w=4.5
X415 g na13 sky130_fd_pr__cap_mim_m3_1 l=4.5 w=4.5
X416 g pa9 pa10 g sky130_fd_pr__nfet_01v8 ad=2.205 pd=5.25 as=3.045 ps=9.85 w=4.2 l=0.55
X417 g pb13 sky130_fd_pr__cap_mim_m3_1 l=4.5 w=4.5
X418 v g20 sp v sky130_fd_pr__pfet_01v8 ad=0.5 pd=2 as=0.5 ps=2 w=1 l=2
X419 sn g20 v v sky130_fd_pr__pfet_01v8 ad=0.5 pd=2 as=0.5 ps=2 w=1 l=2
X420 a_14525_21538# a_13894_23358# v v sky130_fd_pr__pfet_01v8 ad=0.6342 pd=3.19 as=0.882 ps=2.94 w=0.84 l=0.15
X421 a_7984_23358# pb8 g g sky130_fd_pr__nfet_01v8_lvt ad=3.02 pd=9.51 as=4.2 ps=6.1 w=4 l=0.15
X422 nb9 na9 rn v sky130_fd_pr__pfet_01v8_lvt ad=1.218 pd=4.81 as=0.882 ps=2.73 w=1.68 l=0.55
X423 g a_13990_15860# sky130_fd_pr__cap_mim_m3_1 l=4.5 w=4.5
X424 a_3059_23358# pb3 g g sky130_fd_pr__nfet_01v8_lvt ad=3.02 pd=9.51 as=4.2 ps=6.1 w=4 l=0.15
X425 a_24040_21538# a_23409_23358# v v sky130_fd_pr__pfet_01v8 ad=0.6342 pd=3.19 as=0.882 ps=2.94 w=0.84 l=0.15
X426 g pa6 pa7 g sky130_fd_pr__nfet_01v8 ad=2.205 pd=5.25 as=3.045 ps=9.85 w=4.2 l=0.55
X427 a_30975_15860# v g v sky130_fd_pr__pfet_01v8_lvt ad=6.09 pd=18.25 as=4.41 ps=9.45 w=8.4 l=0.55
X428 pb6 pb5 g g sky130_fd_pr__nfet_01v8 ad=3.045 pd=9.85 as=2.205 ps=5.25 w=4.2 l=0.55
X429 v a_26364_20410# n10 v sky130_fd_pr__pfet_01v8 ad=0.882 pd=2.94 as=0.6342 ps=3.19 w=0.84 l=0.15
X430 sn vinp rn sn sky130_fd_pr__pfet_01v8_lvt ad=6 pd=8 as=5.7 ps=13.9 w=6 l=1
X431 rp pa1 pa2 v sky130_fd_pr__pfet_01v8_lvt ad=4.41 pd=9.45 as=6.09 ps=18.25 w=8.4 l=0.55
X432 v a_5029_20410# p5 v sky130_fd_pr__pfet_01v8 ad=0.882 pd=2.94 as=0.6342 ps=3.19 w=0.84 l=0.15
X433 g nb8 sky130_fd_pr__cap_mim_m3_1 l=4.5 w=4.5
X434 rn na3 na4 v sky130_fd_pr__pfet_01v8_lvt ad=4.41 pd=9.45 as=6.09 ps=18.25 w=8.4 l=0.55
X435 a_104_23358# pb0 g g sky130_fd_pr__nfet_01v8_lvt ad=3.02 pd=9.51 as=4.2 ps=6.1 w=4 l=0.15
X436 g pb10 sky130_fd_pr__cap_mim_m3_1 l=4.5 w=4.5
X437 v g20 sp v sky130_fd_pr__pfet_01v8 ad=0.73 pd=3.46 as=0.5 ps=2 w=1 l=2
X438 a_28334_23358# nb12 g g sky130_fd_pr__nfet_01v8_lvt ad=3.02 pd=9.51 as=4.2 ps=6.1 w=4 l=0.15
X439 nb6 na6 rn v sky130_fd_pr__pfet_01v8_lvt ad=1.218 pd=4.81 as=0.882 ps=2.73 w=1.68 l=0.55
X440 sp vb v v sky130_fd_pr__pfet_01v8 ad=0.5 pd=2 as=0.73 ps=3.46 w=1 l=2
X441 v g15 sn v sky130_fd_pr__pfet_01v8 ad=0.5 pd=2 as=0.5 ps=2 w=1 l=2
X442 nb13 na13 rn v sky130_fd_pr__pfet_01v8_lvt ad=1.218 pd=4.81 as=0.882 ps=2.73 w=1.68 l=0.55
X443 nb10 nb9 g g sky130_fd_pr__nfet_01v8 ad=3.045 pd=9.85 as=2.205 ps=5.25 w=4.2 l=0.55
X444 g na10 na11 g sky130_fd_pr__nfet_01v8 ad=2.205 pd=5.25 as=3.045 ps=9.85 w=4.2 l=0.55
X445 v g20 sp v sky130_fd_pr__pfet_01v8 ad=0.5 pd=2 as=0.5 ps=2 w=1 l=2
X446 v a_9954_20410# a_9954_23358# v sky130_fd_pr__pfet_01v8 ad=0.3171 pd=2.35 as=0.3171 ps=2.35 w=0.42 l=2.4
X447 v a_25379_20410# n9 v sky130_fd_pr__pfet_01v8 ad=0.882 pd=2.94 as=0.6342 ps=3.19 w=0.84 l=0.15
X448 a_23055_21538# a_22424_23358# g g sky130_fd_pr__nfet_01v8 ad=0.3171 pd=2.35 as=0.441 ps=2.52 w=0.42 l=0.15
X449 rp pa5 pa6 v sky130_fd_pr__pfet_01v8_lvt ad=4.41 pd=9.45 as=6.09 ps=18.25 w=8.4 l=0.55
X450 pb13 pa13 g g sky130_fd_pr__nfet_01v8 ad=0.609 pd=3.13 as=0.441 ps=1.89 w=0.84 l=0.55
X451 nb2 na2 g g sky130_fd_pr__nfet_01v8 ad=0.609 pd=3.13 as=0.441 ps=1.89 w=0.84 l=0.55
X452 g na5 sky130_fd_pr__cap_mim_m3_1 l=4.5 w=4.5
X453 g a_20454_20410# n4 g sky130_fd_pr__nfet_01v8 ad=0.441 pd=2.52 as=0.3171 ps=2.35 w=0.42 l=0.15
X454 rp pb3 pa3 v sky130_fd_pr__pfet_01v8_lvt ad=0.882 pd=2.73 as=1.218 ps=4.81 w=1.68 l=0.55
X455 g a_4044_20410# p4 g sky130_fd_pr__nfet_01v8 ad=0.441 pd=2.52 as=0.3171 ps=2.35 w=0.42 l=0.15
X456 pb8 pa8 rp v sky130_fd_pr__pfet_01v8_lvt ad=1.218 pd=4.81 as=0.882 ps=2.73 w=1.68 l=0.55
X457 a_4675_21538# a_4044_23358# v v sky130_fd_pr__pfet_01v8 ad=0.6342 pd=3.19 as=0.882 ps=2.94 w=0.84 l=0.15
X458 a_16514_23358# nb0 g g sky130_fd_pr__nfet_01v8_lvt ad=3.02 pd=9.51 as=4.2 ps=6.1 w=4 l=0.15
X459 a_27349_23358# nb11 g g sky130_fd_pr__nfet_01v8_lvt ad=3.02 pd=9.51 as=4.2 ps=6.1 w=4 l=0.15
X460 sp g15 v v sky130_fd_pr__pfet_01v8 ad=0.5 pd=2 as=0.5 ps=2 w=1 l=2
X461 g pb1 sky130_fd_pr__cap_mim_m3_1 l=4.5 w=4.5
X462 v g20 sp v sky130_fd_pr__pfet_01v8 ad=0.73 pd=3.46 as=0.5 ps=2 w=1 l=2
X463 pb10 pa10 g g sky130_fd_pr__nfet_01v8 ad=0.609 pd=3.13 as=0.441 ps=1.89 w=0.84 l=0.55
X464 v a_13894_20410# a_13894_23358# v sky130_fd_pr__pfet_01v8 ad=0.3171 pd=2.35 as=0.3171 ps=2.35 w=0.42 l=2.4
X465 sp g15 v v sky130_fd_pr__pfet_01v8 ad=0.5 pd=2 as=0.73 ps=3.46 w=1 l=2
X466 rn na9 na10 v sky130_fd_pr__pfet_01v8_lvt ad=4.41 pd=9.45 as=6.09 ps=18.25 w=8.4 l=0.55
X467 v a_29319_20410# n13 v sky130_fd_pr__pfet_01v8 ad=0.882 pd=2.94 as=0.6342 ps=3.19 w=0.84 l=0.15
X468 v g20 sn v sky130_fd_pr__pfet_01v8 ad=0.5 pd=2 as=0.5 ps=2 w=1 l=2
X469 a_22070_21538# a_21439_23358# g g sky130_fd_pr__nfet_01v8 ad=0.3171 pd=2.35 as=0.441 ps=2.52 w=0.42 l=0.15
X470 v g a_3306_8498# v sky130_fd_pr__pfet_01v8 ad=0.3486 pd=2.5 as=0.3486 ps=2.5 w=0.42 l=12
X471 rn nb7 na7 v sky130_fd_pr__pfet_01v8_lvt ad=0.882 pd=2.73 as=1.218 ps=4.81 w=1.68 l=0.55
X472 g a_24394_20410# n8 g sky130_fd_pr__nfet_01v8 ad=0.441 pd=2.52 as=0.3171 ps=2.35 w=0.42 l=0.15
X473 g pa3 pa4 g sky130_fd_pr__nfet_01v8 ad=2.205 pd=5.25 as=3.045 ps=9.85 w=4.2 l=0.55
X474 g nb14 na14 g sky130_fd_pr__nfet_01v8 ad=0.441 pd=1.89 as=0.609 ps=3.13 w=0.84 l=0.55
X475 a_8615_21538# a_7984_23358# v v sky130_fd_pr__pfet_01v8 ad=0.6342 pd=3.19 as=0.882 ps=2.94 w=0.84 l=0.15
X476 pb11 pb10 rp v sky130_fd_pr__pfet_01v8_lvt ad=6.09 pd=18.25 as=4.41 ps=9.45 w=8.4 l=0.55
X477 a_3690_21538# a_3059_23358# v v sky130_fd_pr__pfet_01v8 ad=0.6342 pd=3.19 as=0.882 ps=2.94 w=0.84 l=0.15
X478 g na1 sky130_fd_pr__cap_mim_m3_1 l=4.5 w=4.5
X479 g nb3 na3 g sky130_fd_pr__nfet_01v8 ad=0.441 pd=1.89 as=0.609 ps=3.13 w=0.84 l=0.55
X480 nb2 nb1 g g sky130_fd_pr__nfet_01v8 ad=3.045 pd=9.85 as=2.205 ps=5.25 w=4.2 l=0.55
X481 g na2 a_18484_20410# g sky130_fd_pr__nfet_01v8_lvt ad=4.2 pd=6.1 as=3.02 ps=9.51 w=4 l=0.15
X482 v a_12909_20410# a_12909_23358# v sky130_fd_pr__pfet_01v8 ad=0.3171 pd=2.35 as=0.3171 ps=2.35 w=0.42 l=2.4
X483 g a_104_20410# p0 g sky130_fd_pr__nfet_01v8 ad=0.441 pd=2.52 as=0.3171 ps=2.35 w=0.42 l=0.15
X484 sp g15 v v sky130_fd_pr__pfet_01v8 ad=0.5 pd=2 as=0.5 ps=2 w=1 l=2
X485 rp pb9 pa9 v sky130_fd_pr__pfet_01v8_lvt ad=0.882 pd=2.73 as=1.218 ps=4.81 w=1.68 l=0.55
X486 rn nb4 na4 v sky130_fd_pr__pfet_01v8_lvt ad=0.882 pd=2.73 as=1.218 ps=4.81 w=1.68 l=0.55
X487 pb3 pa3 g g sky130_fd_pr__nfet_01v8 ad=0.609 pd=3.13 as=0.441 ps=1.89 w=0.84 l=0.55
X488 v a_11924_23358# a_11924_20410# v sky130_fd_pr__pfet_01v8 ad=0.3171 pd=2.35 as=0.3171 ps=2.35 w=0.42 l=2.4
X489 a_735_21538# a_104_23358# v v sky130_fd_pr__pfet_01v8 ad=0.6342 pd=3.19 as=0.882 ps=2.94 w=0.84 l=0.15
X490 rn nb11 na11 v sky130_fd_pr__pfet_01v8_lvt ad=0.882 pd=2.73 as=1.218 ps=4.81 w=1.68 l=0.55
X491 sn g4 v v sky130_fd_pr__pfet_01v8 ad=0.5 pd=2 as=0.5 ps=2 w=1 l=2
X492 g na7 na8 g sky130_fd_pr__nfet_01v8 ad=2.205 pd=5.25 as=3.045 ps=9.85 w=4.2 l=0.55
X493 nb5 na5 g g sky130_fd_pr__nfet_01v8 ad=0.609 pd=3.13 as=0.441 ps=1.89 w=0.84 l=0.55
X494 g a_28334_20410# n12 g sky130_fd_pr__nfet_01v8 ad=0.441 pd=2.52 as=0.3171 ps=2.35 w=0.42 l=0.15
X495 g a_23409_20410# n7 g sky130_fd_pr__nfet_01v8 ad=0.441 pd=2.52 as=0.3171 ps=2.35 w=0.42 l=0.15
X496 sp g20 v v sky130_fd_pr__pfet_01v8 ad=0.5 pd=2 as=0.73 ps=3.46 w=1 l=2
X497 v a_19469_23358# a_19469_20410# v sky130_fd_pr__pfet_01v8 ad=0.3171 pd=2.35 as=0.3171 ps=2.35 w=0.42 l=2.4
X498 a_28965_21538# a_28334_23358# v v sky130_fd_pr__pfet_01v8 ad=0.6342 pd=3.19 as=0.882 ps=2.94 w=0.84 l=0.15
X499 v g20 sn v sky130_fd_pr__pfet_01v8 ad=0.5 pd=2 as=0.5 ps=2 w=1 l=2
X500 a_14565_15860# v g v sky130_fd_pr__pfet_01v8_lvt ad=6.09 pd=18.25 as=4.41 ps=9.45 w=8.4 l=0.55
X501 g nb0 na0 g sky130_fd_pr__nfet_01v8 ad=0.441 pd=1.89 as=0.609 ps=3.13 w=0.84 l=0.55
X502 a_13540_21538# a_12909_23358# g g sky130_fd_pr__nfet_01v8 ad=0.3171 pd=2.35 as=0.441 ps=2.52 w=0.42 l=0.15
X503 g a_14565_15860# a_13990_15860# v sky130_fd_pr__pfet_01v8_lvt ad=0.882 pd=2.73 as=1.218 ps=4.81 w=1.68 l=0.55
X504 g pb4 sky130_fd_pr__cap_mim_m3_1 l=4.5 w=4.5
X505 g na1 a_17499_20410# g sky130_fd_pr__nfet_01v8_lvt ad=4.2 pd=6.1 as=3.02 ps=9.51 w=4 l=0.15
X506 g pa14 pa0 g sky130_fd_pr__nfet_01v8 ad=2.205 pd=5.25 as=3.045 ps=9.85 w=4.2 l=0.55
X507 rp pb6 pa6 v sky130_fd_pr__pfet_01v8_lvt ad=0.882 pd=2.73 as=1.218 ps=4.81 w=1.68 l=0.55
X508 a_2705_21538# a_2074_23358# g g sky130_fd_pr__nfet_01v8 ad=0.3171 pd=2.35 as=0.441 ps=2.52 w=0.42 l=0.15
X509 g na2 sky130_fd_pr__cap_mim_m3_1 l=4.5 w=4.5
X510 g b1 a_11130_8456# g sky130_fd_pr__nfet_01v8 ad=0.3486 pd=2.5 as=0.3486 ps=2.5 w=0.42 l=0.15
X511 pb0 pa0 g g sky130_fd_pr__nfet_01v8 ad=0.609 pd=3.13 as=0.441 ps=1.89 w=0.84 l=0.55
X512 v a_22424_20410# a_22424_23358# v sky130_fd_pr__pfet_01v8 ad=0.3171 pd=2.35 as=0.3171 ps=2.35 w=0.42 l=2.4
X513 pb7 pa7 g g sky130_fd_pr__nfet_01v8 ad=0.609 pd=3.13 as=0.441 ps=1.89 w=0.84 l=0.55
X514 g a_8969_20410# p9 g sky130_fd_pr__nfet_01v8 ad=0.441 pd=2.52 as=0.3171 ps=2.35 w=0.42 l=0.15
X515 g na11 na12 g sky130_fd_pr__nfet_01v8 ad=2.205 pd=5.25 as=3.045 ps=9.85 w=4.2 l=0.55
X516 v a_10939_23358# a_10939_20410# v sky130_fd_pr__pfet_01v8 ad=0.3171 pd=2.35 as=0.3171 ps=2.35 w=0.42 l=2.4
X517 a_30304_23358# nb14 g g sky130_fd_pr__nfet_01v8_lvt ad=3.02 pd=9.51 as=4.2 ps=6.1 w=4 l=0.15
X518 v g4 sn v sky130_fd_pr__pfet_01v8 ad=0.5 pd=2 as=0.5 ps=2 w=1 l=2
X519 a_30975_15860# a_30400_15860# g v sky130_fd_pr__pfet_01v8_lvt ad=1.218 pd=4.81 as=0.882 ps=2.73 w=1.68 l=0.55
X520 sp g20 v v sky130_fd_pr__pfet_01v8 ad=0.5 pd=2 as=0.5 ps=2 w=1 l=2
X521 a_17145_21538# a_16514_23358# v v sky130_fd_pr__pfet_01v8 ad=0.6342 pd=3.19 as=0.882 ps=2.94 w=0.84 l=0.15
X522 a_27980_21538# a_27349_23358# v v sky130_fd_pr__pfet_01v8 ad=0.6342 pd=3.19 as=0.882 ps=2.94 w=0.84 l=0.15
X523 sn g15 v v sky130_fd_pr__pfet_01v8 ad=0.5 pd=2 as=0.5 ps=2 w=1 l=2
X524 v vb vb v sky130_fd_pr__pfet_01v8 ad=1.66 pd=5.66 as=1.66 ps=5.66 w=2 l=2
X525 vb a_8100_8456# g4 v sky130_fd_pr__pfet_01v8 ad=0.6972 pd=3.34 as=0.6972 ps=3.34 w=0.84 l=0.15
X526 rp pb12 pa12 v sky130_fd_pr__pfet_01v8_lvt ad=0.882 pd=2.73 as=1.218 ps=4.81 w=1.68 l=0.55
X527 sp g20 v v sky130_fd_pr__pfet_01v8 ad=0.5 pd=2 as=0.73 ps=3.46 w=1 l=2
X528 pb13 pb12 g g sky130_fd_pr__nfet_01v8 ad=3.045 pd=9.85 as=2.205 ps=5.25 w=4.2 l=0.55
X529 v a_7984_20410# a_7984_23358# v sky130_fd_pr__pfet_01v8 ad=0.3171 pd=2.35 as=0.3171 ps=2.35 w=0.42 l=2.4
X530 pb4 pa4 g g sky130_fd_pr__nfet_01v8 ad=0.609 pd=3.13 as=0.441 ps=1.89 w=0.84 l=0.55
X531 nb11 na11 g g sky130_fd_pr__nfet_01v8 ad=0.609 pd=3.13 as=0.441 ps=1.89 w=0.84 l=0.55
X532 a_1720_21538# a_1089_23358# g g sky130_fd_pr__nfet_01v8 ad=0.3171 pd=2.35 as=0.441 ps=2.52 w=0.42 l=0.15
X533 v a_3059_20410# a_3059_23358# v sky130_fd_pr__pfet_01v8 ad=0.3171 pd=2.35 as=0.3171 ps=2.35 w=0.42 l=2.4
X534 v a_21439_20410# a_21439_23358# v sky130_fd_pr__pfet_01v8 ad=0.3171 pd=2.35 as=0.3171 ps=2.35 w=0.42 l=2.4
X535 v a_2074_23358# a_2074_20410# v sky130_fd_pr__pfet_01v8 ad=0.3171 pd=2.35 as=0.3171 ps=2.35 w=0.42 l=2.4
X536 nb1 na1 rn v sky130_fd_pr__pfet_01v8_lvt ad=1.218 pd=4.81 as=0.882 ps=2.73 w=1.68 l=0.55
X537 pb5 pb4 rp v sky130_fd_pr__pfet_01v8_lvt ad=6.09 pd=18.25 as=4.41 ps=9.45 w=8.4 l=0.55
X538 g pb1 pa1 g sky130_fd_pr__nfet_01v8 ad=0.441 pd=1.89 as=0.609 ps=3.13 w=0.84 l=0.55
X539 v g15 sp v sky130_fd_pr__pfet_01v8 ad=0.5 pd=2 as=0.5 ps=2 w=1 l=2
X540 nb7 nb6 rn v sky130_fd_pr__pfet_01v8_lvt ad=6.09 pd=18.25 as=4.41 ps=9.45 w=8.4 l=0.55
X541 v g15 sn v sky130_fd_pr__pfet_01v8 ad=0.5 pd=2 as=0.5 ps=2 w=1 l=2
X542 v a_18484_20410# n2 v sky130_fd_pr__pfet_01v8 ad=0.882 pd=2.94 as=0.6342 ps=3.19 w=0.84 l=0.15
X543 a_26995_21538# a_26364_23358# g g sky130_fd_pr__nfet_01v8 ad=0.3171 pd=2.35 as=0.441 ps=2.52 w=0.42 l=0.15
X544 nb8 na8 g g sky130_fd_pr__nfet_01v8 ad=0.609 pd=3.13 as=0.441 ps=1.89 w=0.84 l=0.55
X545 sp g20 v v sky130_fd_pr__pfet_01v8 ad=0.5 pd=2 as=0.5 ps=2 w=1 l=2
X546 g nb9 sky130_fd_pr__cap_mim_m3_1 l=4.5 w=4.5
X547 sn g20 v v sky130_fd_pr__pfet_01v8 ad=0.5 pd=2 as=0.5 ps=2 w=1 l=2
X548 v a_6999_20410# a_6999_23358# v sky130_fd_pr__pfet_01v8 ad=0.3171 pd=2.35 as=0.3171 ps=2.35 w=0.42 l=2.4
X549 rp pa12 pa13 v sky130_fd_pr__pfet_01v8_lvt ad=4.41 pd=9.45 as=6.09 ps=18.25 w=8.4 l=0.55
X550 pb12 pb11 rp v sky130_fd_pr__pfet_01v8_lvt ad=6.09 pd=18.25 as=4.41 ps=9.45 w=8.4 l=0.55
X551 v a_6014_23358# a_6014_20410# v sky130_fd_pr__pfet_01v8 ad=0.3171 pd=2.35 as=0.3171 ps=2.35 w=0.42 l=2.4
X552 g pa2 sky130_fd_pr__cap_mim_m3_1 l=4.5 w=4.5
X553 g na6 sky130_fd_pr__cap_mim_m3_1 l=4.5 w=4.5
X554 v a_8100_8456# a_8706_8456# v sky130_fd_pr__pfet_01v8 ad=0.6972 pd=3.34 as=0.6972 ps=3.34 w=0.84 l=0.15
X555 v a_1089_23358# a_1089_20410# v sky130_fd_pr__pfet_01v8 ad=0.3171 pd=2.35 as=0.3171 ps=2.35 w=0.42 l=2.4
X556 a_22424_23358# nb6 g g sky130_fd_pr__nfet_01v8_lvt ad=3.02 pd=9.51 as=4.2 ps=6.1 w=4 l=0.15
X557 g pb11 sky130_fd_pr__cap_mim_m3_1 l=4.5 w=4.5
X558 g na11 sky130_fd_pr__cap_mim_m3_1 l=4.5 w=4.5
X559 nb4 nb3 g g sky130_fd_pr__nfet_01v8 ad=3.045 pd=9.85 as=2.205 ps=5.25 w=4.2 l=0.55
X560 g na2 na3 g sky130_fd_pr__nfet_01v8 ad=2.205 pd=5.25 as=3.045 ps=9.85 w=4.2 l=0.55
X561 g na4 a_20454_20410# g sky130_fd_pr__nfet_01v8_lvt ad=4.2 pd=6.1 as=3.02 ps=9.51 w=4 l=0.15
X562 pb9 pb8 rp v sky130_fd_pr__pfet_01v8_lvt ad=6.09 pd=18.25 as=4.41 ps=9.45 w=8.4 l=0.55
X563 g pb5 pa5 g sky130_fd_pr__nfet_01v8 ad=0.441 pd=1.89 as=0.609 ps=3.13 w=0.84 l=0.55
X564 rn vinp sn sn sky130_fd_pr__pfet_01v8_lvt ad=5.7 pd=13.9 as=6 ps=8 w=6 l=1
X565 g pa4 a_4044_20410# g sky130_fd_pr__nfet_01v8_lvt ad=4.2 pd=6.1 as=3.02 ps=9.51 w=4 l=0.15
X566 a_7630_21538# a_6999_23358# g g sky130_fd_pr__nfet_01v8 ad=0.3171 pd=2.35 as=0.441 ps=2.52 w=0.42 l=0.15
X567 sp g4 v v sky130_fd_pr__pfet_01v8 ad=0.5 pd=2 as=0.5 ps=2 w=1 l=2
X568 nb12 na12 g g sky130_fd_pr__nfet_01v8 ad=0.609 pd=3.13 as=0.441 ps=1.89 w=0.84 l=0.55
X569 v a_17499_20410# n1 v sky130_fd_pr__pfet_01v8 ad=0.882 pd=2.94 as=0.6342 ps=3.19 w=0.84 l=0.15
X570 v a_27349_20410# a_27349_23358# v sky130_fd_pr__pfet_01v8 ad=0.3171 pd=2.35 as=0.3171 ps=2.35 w=0.42 l=2.4
X571 a_26010_21538# a_25379_23358# g g sky130_fd_pr__nfet_01v8 ad=0.3171 pd=2.35 as=0.441 ps=2.52 w=0.42 l=0.15
X572 pb3 pb2 g g sky130_fd_pr__nfet_01v8 ad=3.045 pd=9.85 as=2.205 ps=5.25 w=4.2 l=0.55
X573 g a_30304_20410# n14 g sky130_fd_pr__nfet_01v8 ad=0.441 pd=2.52 as=0.3171 ps=2.35 w=0.42 l=0.15
X574 v g15 sp v sky130_fd_pr__pfet_01v8 ad=0.5 pd=2 as=0.5 ps=2 w=1 l=2
X575 v a_26364_23358# a_26364_20410# v sky130_fd_pr__pfet_01v8 ad=0.3171 pd=2.35 as=0.3171 ps=2.35 w=0.42 l=2.4
X576 a_30935_21538# a_30304_23358# v v sky130_fd_pr__pfet_01v8 ad=0.6342 pd=3.19 as=0.882 ps=2.94 w=0.84 l=0.15
X577 v g20 sn v sky130_fd_pr__pfet_01v8 ad=0.5 pd=2 as=0.5 ps=2 w=1 l=2
X578 v b0 a_10524_8456# v sky130_fd_pr__pfet_01v8 ad=0.6972 pd=3.34 as=0.6972 ps=3.34 w=0.84 l=0.15
X579 v a_5029_23358# a_5029_20410# v sky130_fd_pr__pfet_01v8 ad=0.3171 pd=2.35 as=0.3171 ps=2.35 w=0.42 l=2.4
X580 g pb11 pa11 g sky130_fd_pr__nfet_01v8 ad=0.441 pd=1.89 as=0.609 ps=3.13 w=0.84 l=0.55
X581 g pa10 pa11 g sky130_fd_pr__nfet_01v8 ad=2.205 pd=5.25 as=3.045 ps=9.85 w=4.2 l=0.55
X582 a_21439_23358# nb5 g g sky130_fd_pr__nfet_01v8_lvt ad=3.02 pd=9.51 as=4.2 ps=6.1 w=4 l=0.15
X583 sn g20 v v sky130_fd_pr__pfet_01v8 ad=0.5 pd=2 as=0.5 ps=2 w=1 l=2
X584 g pb2 pa2 g sky130_fd_pr__nfet_01v8 ad=0.441 pd=1.89 as=0.609 ps=3.13 w=0.84 l=0.55
X585 g nb9 na9 g sky130_fd_pr__nfet_01v8 ad=0.441 pd=1.89 as=0.609 ps=3.13 w=0.84 l=0.55
X586 g na8 a_24394_20410# g sky130_fd_pr__nfet_01v8_lvt ad=4.2 pd=6.1 as=3.02 ps=9.51 w=4 l=0.15
X587 rn na1 na2 v sky130_fd_pr__pfet_01v8_lvt ad=4.41 pd=9.45 as=6.09 ps=18.25 w=8.4 l=0.55
X588 a_19115_21538# a_18484_23358# g g sky130_fd_pr__nfet_01v8 ad=0.3171 pd=2.35 as=0.441 ps=2.52 w=0.42 l=0.15
X589 pb7 pb6 g g sky130_fd_pr__nfet_01v8 ad=3.045 pd=9.85 as=2.205 ps=5.25 w=4.2 l=0.55
X590 g na13 na14 g sky130_fd_pr__nfet_01v8 ad=2.205 pd=5.25 as=3.045 ps=9.85 w=4.2 l=0.55
X591 a_14565_15860# a_13990_15860# g v sky130_fd_pr__pfet_01v8_lvt ad=1.218 pd=4.81 as=0.882 ps=2.73 w=1.68 l=0.55
X592 v a_25379_23358# a_25379_20410# v sky130_fd_pr__pfet_01v8 ad=0.3171 pd=2.35 as=0.3171 ps=2.35 w=0.42 l=2.4
X593 g a_16514_20410# n0 g sky130_fd_pr__nfet_01v8 ad=0.441 pd=2.52 as=0.3171 ps=2.35 w=0.42 l=0.15
X594 rp pa2 pa3 v sky130_fd_pr__pfet_01v8_lvt ad=4.41 pd=9.45 as=6.09 ps=18.25 w=8.4 l=0.55
X595 sp g15 v v sky130_fd_pr__pfet_01v8 ad=0.5 pd=2 as=0.5 ps=2 w=1 l=2
X596 pb2 pb1 rp v sky130_fd_pr__pfet_01v8_lvt ad=6.09 pd=18.25 as=4.41 ps=9.45 w=8.4 l=0.55
X597 rn na4 na5 v sky130_fd_pr__pfet_01v8_lvt ad=4.41 pd=9.45 as=6.09 ps=18.25 w=8.4 l=0.55
X598 g pa0 a_104_20410# g sky130_fd_pr__nfet_01v8_lvt ad=4.2 pd=6.1 as=3.02 ps=9.51 w=4 l=0.15
X599 g nb6 na6 g sky130_fd_pr__nfet_01v8 ad=0.441 pd=1.89 as=0.609 ps=3.13 w=0.84 l=0.55
X600 v g20 sp v sky130_fd_pr__pfet_01v8 ad=0.5 pd=2 as=0.5 ps=2 w=1 l=2
X601 g nb13 na13 g sky130_fd_pr__nfet_01v8 ad=0.441 pd=1.89 as=0.609 ps=3.13 w=0.84 l=0.55
X602 g na12 a_28334_20410# g sky130_fd_pr__nfet_01v8_lvt ad=4.2 pd=6.1 as=3.02 ps=9.51 w=4 l=0.15
X603 g a_30400_15860# sky130_fd_pr__cap_mim_m3_1 l=4.5 w=4.5
X604 g nb2 sky130_fd_pr__cap_mim_m3_1 l=4.5 w=4.5
X605 v g20 sn v sky130_fd_pr__pfet_01v8 ad=0.5 pd=2 as=0.5 ps=2 w=1 l=2
X606 rp pa9 pa10 v sky130_fd_pr__pfet_01v8_lvt ad=4.41 pd=9.45 as=6.09 ps=18.25 w=8.4 l=0.55
X607 g na7 a_23409_20410# g sky130_fd_pr__nfet_01v8_lvt ad=4.2 pd=6.1 as=3.02 ps=9.51 w=4 l=0.15
X608 nb11 nb10 g g sky130_fd_pr__nfet_01v8 ad=3.045 pd=9.85 as=2.205 ps=5.25 w=4.2 l=0.55
X609 pb12 pa12 rp v sky130_fd_pr__pfet_01v8_lvt ad=1.218 pd=4.81 as=0.882 ps=2.73 w=1.68 l=0.55
X610 g a_2330_8340# a_3306_8498# g sky130_fd_pr__nfet_01v8_lvt ad=4.15 pd=11.66 as=4.15 ps=11.66 w=5 l=0.15
X611 a_12909_23358# pb13 g g sky130_fd_pr__nfet_01v8_lvt ad=3.02 pd=9.51 as=4.2 ps=6.1 w=4 l=0.15
X612 g na14 na0 g sky130_fd_pr__nfet_01v8 ad=2.205 pd=5.25 as=3.045 ps=9.85 w=4.2 l=0.55
X613 v a_29319_23358# a_29319_20410# v sky130_fd_pr__pfet_01v8 ad=0.3171 pd=2.35 as=0.3171 ps=2.35 w=0.42 l=2.4
X614 rp pa6 pa7 v sky130_fd_pr__pfet_01v8_lvt ad=4.41 pd=9.45 as=6.09 ps=18.25 w=8.4 l=0.55
X615 pb6 pb5 rp v sky130_fd_pr__pfet_01v8_lvt ad=6.09 pd=18.25 as=4.41 ps=9.45 w=8.4 l=0.55
X616 g a_6282_8456# a_8100_8456# g sky130_fd_pr__nfet_01v8 ad=0.3486 pd=2.5 as=0.3486 ps=2.5 w=0.42 l=0.15
X617 g pb8 pa8 g sky130_fd_pr__nfet_01v8 ad=0.441 pd=1.89 as=0.609 ps=3.13 w=0.84 l=0.55
X618 a_23055_21538# a_22424_23358# v v sky130_fd_pr__pfet_01v8 ad=0.6342 pd=3.19 as=0.882 ps=2.94 w=0.84 l=0.15
X619 a_2074_23358# pb2 g g sky130_fd_pr__nfet_01v8_lvt ad=3.02 pd=9.51 as=4.2 ps=6.1 w=4 l=0.15
X620 sn g15 v v sky130_fd_pr__pfet_01v8 ad=0.5 pd=2 as=0.5 ps=2 w=1 l=2
X621 sn vinp rn sn sky130_fd_pr__pfet_01v8_lvt ad=6 pd=8 as=5.7 ps=13.9 w=6 l=1
X622 g nb10 na10 g sky130_fd_pr__nfet_01v8 ad=0.441 pd=1.89 as=0.609 ps=3.13 w=0.84 l=0.55
X623 v a_20454_20410# n4 v sky130_fd_pr__pfet_01v8 ad=0.882 pd=2.94 as=0.6342 ps=3.19 w=0.84 l=0.15
X624 g pa9 a_8969_20410# g sky130_fd_pr__nfet_01v8_lvt ad=4.2 pd=6.1 as=3.02 ps=9.51 w=4 l=0.15
X625 sp g20 v v sky130_fd_pr__pfet_01v8 ad=0.5 pd=2 as=0.5 ps=2 w=1 l=2
X626 v a_4044_20410# p4 v sky130_fd_pr__pfet_01v8 ad=0.882 pd=2.94 as=0.6342 ps=3.19 w=0.84 l=0.15
X627 g a_9954_20410# p10 g sky130_fd_pr__nfet_01v8 ad=0.441 pd=2.52 as=0.3171 ps=2.35 w=0.42 l=0.15
X628 g pb5 sky130_fd_pr__cap_mim_m3_1 l=4.5 w=4.5
X629 v g20 sp v sky130_fd_pr__pfet_01v8 ad=0.5 pd=2 as=0.5 ps=2 w=1 l=2
X630 g pb14 pa14 g sky130_fd_pr__nfet_01v8 ad=0.441 pd=1.89 as=0.609 ps=3.13 w=0.84 l=0.55
X631 rn na10 na11 v sky130_fd_pr__pfet_01v8_lvt ad=4.41 pd=9.45 as=6.09 ps=18.25 w=8.4 l=0.55
X632 g pa7 sky130_fd_pr__cap_mim_m3_1 l=4.5 w=4.5
X633 nb10 nb9 rn v sky130_fd_pr__pfet_01v8_lvt ad=6.09 pd=18.25 as=4.41 ps=9.45 w=8.4 l=0.55
X634 nb7 na7 rn v sky130_fd_pr__pfet_01v8_lvt ad=1.218 pd=4.81 as=0.882 ps=2.73 w=1.68 l=0.55
X635 v b1 a_6888_8456# v sky130_fd_pr__pfet_01v8 ad=0.6972 pd=3.34 as=0.6972 ps=3.34 w=0.84 l=0.15
X636 a_1089_23358# pb1 g g sky130_fd_pr__nfet_01v8_lvt ad=3.02 pd=9.51 as=4.2 ps=6.1 w=4 l=0.15
X637 a_22070_21538# a_21439_23358# v v sky130_fd_pr__pfet_01v8 ad=0.6342 pd=3.19 as=0.882 ps=2.94 w=0.84 l=0.15
X638 g pa13 sky130_fd_pr__cap_mim_m3_1 l=4.5 w=4.5
X639 g pa4 pa5 g sky130_fd_pr__nfet_01v8 ad=2.205 pd=5.25 as=3.045 ps=9.85 w=4.2 l=0.55
X640 v a_24394_20410# n8 v sky130_fd_pr__pfet_01v8 ad=0.882 pd=2.94 as=0.6342 ps=3.19 w=0.84 l=0.15
X641 nb14 na14 g g sky130_fd_pr__nfet_01v8 ad=0.609 pd=3.13 as=0.441 ps=1.89 w=0.84 l=0.55
X642 rn nb2 na2 v sky130_fd_pr__pfet_01v8_lvt ad=0.882 pd=2.73 as=1.218 ps=4.81 w=1.68 l=0.55
X643 g a_13894_20410# p14 g sky130_fd_pr__nfet_01v8 ad=0.441 pd=2.52 as=0.3171 ps=2.35 w=0.42 l=0.15
X644 v g4 sp v sky130_fd_pr__pfet_01v8 ad=0.5 pd=2 as=0.5 ps=2 w=1 l=2
X645 sn g15 v v sky130_fd_pr__pfet_01v8 ad=0.5 pd=2 as=0.5 ps=2 w=1 l=2
X646 g pb2 sky130_fd_pr__cap_mim_m3_1 l=4.5 w=4.5
X647 g nb6 sky130_fd_pr__cap_mim_m3_1 l=4.5 w=4.5
X648 g b0 a_6282_8456# g sky130_fd_pr__nfet_01v8 ad=0.3486 pd=2.5 as=0.3486 ps=2.5 w=0.42 l=0.15
X649 nb3 na3 g g sky130_fd_pr__nfet_01v8 ad=0.609 pd=3.13 as=0.441 ps=1.89 w=0.84 l=0.55
X650 nb3 nb2 g g sky130_fd_pr__nfet_01v8 ad=3.045 pd=9.85 as=2.205 ps=5.25 w=4.2 l=0.55
X651 sp g20 v v sky130_fd_pr__pfet_01v8 ad=0.5 pd=2 as=0.5 ps=2 w=1 l=2
X652 pb2 pa2 rp v sky130_fd_pr__pfet_01v8_lvt ad=1.218 pd=4.81 as=0.882 ps=2.73 w=1.68 l=0.55
X653 a_26364_23358# nb10 g g sky130_fd_pr__nfet_01v8_lvt ad=3.02 pd=9.51 as=4.2 ps=6.1 w=4 l=0.15
X654 nb4 na4 rn v sky130_fd_pr__pfet_01v8_lvt ad=1.218 pd=4.81 as=0.882 ps=2.73 w=1.68 l=0.55
X655 pb9 pa9 rp v sky130_fd_pr__pfet_01v8_lvt ad=1.218 pd=4.81 as=0.882 ps=2.73 w=1.68 l=0.55
X656 v a_104_20410# p0 v sky130_fd_pr__pfet_01v8 ad=0.882 pd=2.94 as=0.6342 ps=3.19 w=0.84 l=0.15
X657 g pa8 sky130_fd_pr__cap_mim_m3_1 l=4.5 w=4.5
X658 g a_12342_8456# a_12948_8456# g sky130_fd_pr__nfet_01v8 ad=0.3486 pd=2.5 as=0.3486 ps=2.5 w=0.42 l=0.15
X659 nb8 nb7 g g sky130_fd_pr__nfet_01v8 ad=3.045 pd=9.85 as=2.205 ps=5.25 w=4.2 l=0.55
X660 g na8 na9 g sky130_fd_pr__nfet_01v8 ad=2.205 pd=5.25 as=3.045 ps=9.85 w=4.2 l=0.55
X661 g na12 sky130_fd_pr__cap_mim_m3_1 l=4.5 w=4.5
X662 v a_28334_20410# n12 v sky130_fd_pr__pfet_01v8 ad=0.882 pd=2.94 as=0.6342 ps=3.19 w=0.84 l=0.15
X663 v a_23409_20410# n7 v sky130_fd_pr__pfet_01v8 ad=0.882 pd=2.94 as=0.6342 ps=3.19 w=0.84 l=0.15
X664 a_21085_21538# a_20454_23358# g g sky130_fd_pr__nfet_01v8 ad=0.3171 pd=2.35 as=0.441 ps=2.52 w=0.42 l=0.15
X665 g pa14 sky130_fd_pr__cap_mim_m3_1 l=4.5 w=4.5
X666 g pa13 pa14 g sky130_fd_pr__nfet_01v8 ad=2.205 pd=5.25 as=3.045 ps=9.85 w=4.2 l=0.55
X667 rp pa3 pa4 v sky130_fd_pr__pfet_01v8_lvt ad=4.41 pd=9.45 as=6.09 ps=18.25 w=8.4 l=0.55
X668 pb11 pa11 g g sky130_fd_pr__nfet_01v8 ad=0.609 pd=3.13 as=0.441 ps=1.89 w=0.84 l=0.55
X669 nb0 na0 g g sky130_fd_pr__nfet_01v8 ad=0.609 pd=3.13 as=0.441 ps=1.89 w=0.84 l=0.55
X670 g a_12909_20410# p13 g sky130_fd_pr__nfet_01v8 ad=0.441 pd=2.52 as=0.3171 ps=2.35 w=0.42 l=0.15
X671 v a_12948_8456# g15 v sky130_fd_pr__pfet_01v8 ad=0.6972 pd=3.34 as=0.6972 ps=3.34 w=0.84 l=0.15
X672 a_13540_21538# a_12909_23358# v v sky130_fd_pr__pfet_01v8 ad=0.6342 pd=3.19 as=0.882 ps=2.94 w=0.84 l=0.15
X673 g pa0 pa1 g sky130_fd_pr__nfet_01v8 ad=2.205 pd=5.25 as=3.045 ps=9.85 w=4.2 l=0.55
X674 pb0 pb14 g g sky130_fd_pr__nfet_01v8 ad=3.045 pd=9.85 as=2.205 ps=5.25 w=4.2 l=0.55
X675 pb6 pa6 rp v sky130_fd_pr__pfet_01v8_lvt ad=1.218 pd=4.81 as=0.882 ps=2.73 w=1.68 l=0.55
X676 a_6999_23358# pb7 g g sky130_fd_pr__nfet_01v8_lvt ad=3.02 pd=9.51 as=4.2 ps=6.1 w=4 l=0.15
X677 nb2 nb1 rn v sky130_fd_pr__pfet_01v8_lvt ad=6.09 pd=18.25 as=4.41 ps=9.45 w=8.4 l=0.55
X678 a_2705_21538# a_2074_23358# v v sky130_fd_pr__pfet_01v8 ad=0.6342 pd=3.19 as=0.882 ps=2.94 w=0.84 l=0.15
X679 v g15 sp v sky130_fd_pr__pfet_01v8 ad=0.5 pd=2 as=0.5 ps=2 w=1 l=2
X680 a_25379_23358# nb9 g g sky130_fd_pr__nfet_01v8_lvt ad=3.02 pd=9.51 as=4.2 ps=6.1 w=4 l=0.15
X681 sn g20 v v sky130_fd_pr__pfet_01v8 ad=0.5 pd=2 as=0.5 ps=2 w=1 l=2
X682 g a_30975_15860# a_30400_15860# g sky130_fd_pr__nfet_01v8 ad=0.441 pd=1.89 as=0.609 ps=3.13 w=0.84 l=0.55
X683 g na14 a_30304_20410# g sky130_fd_pr__nfet_01v8_lvt ad=4.2 pd=6.1 as=3.02 ps=9.51 w=4 l=0.15
X684 nb12 nb11 g g sky130_fd_pr__nfet_01v8 ad=3.045 pd=9.85 as=2.205 ps=5.25 w=4.2 l=0.55
X685 g na12 na13 g sky130_fd_pr__nfet_01v8 ad=2.205 pd=5.25 as=3.045 ps=9.85 w=4.2 l=0.55
X686 v a_11924_20410# a_11924_23358# v sky130_fd_pr__pfet_01v8 ad=0.3171 pd=2.35 as=0.3171 ps=2.35 w=0.42 l=2.4
X687 v a_8969_20410# p9 v sky130_fd_pr__pfet_01v8 ad=0.882 pd=2.94 as=0.6342 ps=3.19 w=0.84 l=0.15
X688 rn na7 na8 v sky130_fd_pr__pfet_01v8_lvt ad=4.41 pd=9.45 as=6.09 ps=18.25 w=8.4 l=0.55
X689 g pa1 sky130_fd_pr__cap_mim_m3_1 l=4.5 w=4.5
X690 a_20100_21538# a_19469_23358# g g sky130_fd_pr__nfet_01v8 ad=0.3171 pd=2.35 as=0.441 ps=2.52 w=0.42 l=0.15
X691 rn nb5 na5 v sky130_fd_pr__pfet_01v8_lvt ad=0.882 pd=2.73 as=1.218 ps=4.81 w=1.68 l=0.55
X692 v a_19469_20410# a_19469_23358# v sky130_fd_pr__pfet_01v8 ad=0.3171 pd=2.35 as=0.3171 ps=2.35 w=0.42 l=2.4
X693 g a_22424_20410# n6 g sky130_fd_pr__nfet_01v8 ad=0.441 pd=2.52 as=0.3171 ps=2.35 w=0.42 l=0.15
X694 nb10 na10 rn v sky130_fd_pr__pfet_01v8_lvt ad=1.218 pd=4.81 as=0.882 ps=2.73 w=1.68 l=0.55
X695 v a_18484_23358# a_18484_20410# v sky130_fd_pr__pfet_01v8 ad=0.3171 pd=2.35 as=0.3171 ps=2.35 w=0.42 l=2.4
C0 a_12342_8456# a_6282_8456# 0.20388f
C1 mid a_12342_8456# 0.01523f
C2 a_8969_23358# a_7984_20410# 0
C3 pb12 pb13 0.95149f
C4 refmid rp 0.01808f
C5 a_19115_21538# n2 0.06989f
C6 rp b1 0.31576f
C7 na13 n13 0.02889f
C8 vinn rp 1.58864f
C9 a_8706_8456# vinp 0.06325f
C10 b0 rp 0.30883f
C11 na9 n9 0.02889f
C12 p10 a_9600_21538# 0.06334f
C13 a_13554_8456# rn 0.12371f
C14 a_10524_8456# a_6888_8456# 0
C15 pb3 pb4 1.01031f
C16 a_13554_8456# na5 0
C17 a_6888_8456# rn 0.16507f
C18 na0 nb1 0.07116f
C19 refmid a_8706_8456# 0.00505f
C20 pb12 pa12 5.42409f
C21 a_9954_20410# pb10 0.01581f
C22 nb3 nb2 0.93174f
C23 a_26364_23358# a_26995_21538# 0.20585f
C24 p9 a_9600_21538# 0.06989f
C25 a_6282_8456# a_7494_8456# 0.00811f
C26 p6 p7 0.05837f
C27 a_8706_8456# vinn 0.06018f
C28 a_8706_8456# b1 0.2308f
C29 mid a_7494_8456# 0.02647f
C30 na9 n8 0.00118f
C31 v na1 2.09659f
C32 vb na4 0.00249f
C33 mid sp 0.5778f
C34 b0 a_8706_8456# 0.01957f
C35 sp a_6282_8456# 0
C36 na0 a_11130_8456# 0.00273f
C37 nb0 a_17499_20410# 0.00413f
C38 g15 a_8100_8456# 0.20352f
C39 nb14 na11 0
C40 a_2330_8340# a_6282_8456# 0.27405f
C41 a_20454_23358# na4 0.00117f
C42 a_6014_23358# p7 0.00455f
C43 a_1089_20410# a_735_21538# 0.00308f
C44 pa1 pa0 1.0236f
C45 a_11924_20410# p13 0
C46 a_6014_20410# pb6 0.01581f
C47 na13 n12 0.00118f
C48 p6 p5 0.05837f
C49 mid a_3306_8498# 0.00318f
C50 a_6282_8456# a_3306_8498# 3.20703f
C51 a_11924_20410# p12 0.28604f
C52 nb9 nb10 1.02201f
C53 a_7494_8456# a_9312_8456# 0
C54 nb2 a_19115_21538# 0.001f
C55 vb vinp 0.02558f
C56 pb3 p2 0
C57 a_6014_23358# p6 0.514f
C58 rp a_8100_8456# 0.06218f
C59 a_6014_23358# p5 0.01804f
C60 sp a_9312_8456# 0
C61 p4 p5 0.05837f
C62 a_12342_8456# a_11130_8456# 0.65381f
C63 a_18130_21538# a_18484_20410# 0.00308f
C64 a_11924_20410# p11 0.22722f
C65 pb1 pa0 0.07089f
C66 refmid vb 0.28512f
C67 vb b1 0.31841f
C68 vb vinn 0.04111f
C69 n5 nb5 0.03003f
C70 v a_18484_23358# 2.30543f
C71 pb3 pb14 0
C72 pb5 a_4044_23358# 0.00181f
C73 b0 vb 0.15179f
C74 a_8706_8456# a_8100_8456# 0.48492f
C75 a_16514_23358# a_17145_21538# 0.20585f
C76 pa8 rp 1.30791f
C77 a_9312_8456# a_3306_8498# 0
C78 a_6999_23358# a_7984_20410# 0.12679f
C79 pb4 p3 0
C80 a_30304_20410# v 1.89792f
C81 sp a_11130_8456# 0
C82 a_2330_8340# nb1 0
C83 na6 n6 0.02883f
C84 pa14 pa1 0.00137f
C85 na14 nb10 0
C86 pa14 a_13990_15860# 0.06843f
C87 a_2330_8340# a_11130_8456# 1.99275f
C88 nb2 rs 0
C89 nb5 n4 0
C90 a_11130_8456# a_3306_8498# 0.15959f
C91 g20 rs 1.0619f
C92 a_8969_20410# a_8969_23358# 0.41634f
C93 nb13 n13 0.03003f
C94 a_2330_8340# pb9 0
C95 pb3 a_3690_21538# 0.001f
C96 pa5 a_5029_23358# 0.00495f
C97 pb11 p11 0.03003f
C98 pa7 pb9 0.01292f
C99 pa14 pb1 0
C100 p2 a_3059_23358# 0.01804f
C101 v pa1 2.35828f
C102 vb a_8100_8456# 2.18471f
C103 p2 p3 0.05837f
C104 n5 na6 0.00118f
C105 v a_13990_15860# 2.80545f
C106 p10 pb11 0
C107 pb3 a_2074_23358# 0.00181f
C108 na14 na4 0.00328f
C109 pa10 pb11 0.08313f
C110 pb3 pa5 0.09247f
C111 na9 nb8 1.81154f
C112 a_28965_21538# n13 0.06334f
C113 a_7984_23358# a_8969_23358# 0.02326f
C114 na4 na2 0.02209f
C115 a_9954_20410# a_8969_20410# 0.02905f
C116 nb5 nb8 0
C117 vb pa8 0.00156f
C118 pb1 v 2.39715f
C119 na3 na1 0.03135f
C120 pa13 a_11924_23358# 0.00428f
C121 a_2330_8340# na0 0.00201f
C122 a_30304_20410# a_30304_23358# 0.41634f
C123 nb13 n12 0
C124 na14 vinp 0
C125 a_12948_8456# a_6282_8456# 0.13979f
C126 nb4 v 2.12046f
C127 a_8969_23358# pb9 0.36868f
C128 nb7 na7 5.18114f
C129 nb9 a_25379_20410# 0.01281f
C130 a_21439_23358# a_22424_23358# 0.02326f
C131 nb12 nb11 1.02201f
C132 a_18484_20410# a_18484_23358# 0.2858f
C133 vinn na14 0
C134 sp a_12342_8456# 0
C135 n14 na14 0.02883f
C136 na8 na7 1.01092f
C137 a_28965_21538# n12 0.06989f
C138 pa1 pb2 0.1569f
C139 a_3690_21538# a_3059_23358# 0.20585f
C140 a_735_21538# a_104_20410# 0.0013f
C141 a_13554_8456# na4 0
C142 p3 a_3690_21538# 0.06989f
C143 pb14 b1 0
C144 p9 a_8615_21538# 0.06334f
C145 a_9954_20410# pb9 0.00413f
C146 a_2330_8340# a_12342_8456# 0.27304f
C147 p1 a_1720_21538# 0.06989f
C148 v a_1089_20410# 1.91491f
C149 b0 pb14 0
C150 p3 a_2074_23358# 0.00455f
C151 n13 na14 0.00118f
C152 pa14 pa9 0
C153 a_2074_23358# a_3059_23358# 0.02326f
C154 nb8 na6 0.00592f
C155 na7 nb14 0
C156 a_12342_8456# a_3306_8498# 0.22179f
C157 g20 a_9918_8456# 0.38423f
C158 na3 a_18484_23358# 0.00428f
C159 sp a_7494_8456# 0
C160 a_22424_20410# n7 0
C161 a_13554_8456# vinp 0.00269f
C162 pb1 pb2 1.00047f
C163 p8 a_8615_21538# 0.06989f
C164 a_26010_21538# a_26364_20410# 0.00308f
C165 vinp a_6888_8456# 0.003f
C166 a_2330_8340# pb5 0
C167 a_2330_8340# sp 0
C168 a_12948_8456# a_11130_8456# 0.16327f
C169 pa14 pa4 0.00328f
C170 a_22424_20410# n6 0.28604f
C171 pb5 pa7 0.11205f
C172 a_12909_20410# a_12909_23358# 0.41634f
C173 a_7984_23358# a_6999_23358# 0.02326f
C174 a_7494_8456# a_3306_8498# 0.00153f
C175 pa9 v 2.05555f
C176 refmid a_13554_8456# 0
C177 na14 a_8100_8456# 0
C178 pa14 pb6 0
C179 a_13554_8456# b1 0.06253f
C180 refmid a_6888_8456# 0.00722f
C181 b1 a_6888_8456# 0.35291f
C182 sp a_3306_8498# 0
C183 a_13554_8456# vinn 0.04497f
C184 a_2330_8340# pa7 0
C185 vinn a_6888_8456# 0.0064f
C186 b0 a_13554_8456# 0.00754f
C187 n14 a_30935_21538# 0.06989f
C188 a_9954_23358# p11 0.00455f
C189 v a_4044_20410# 1.91294f
C190 nb3 a_20454_20410# 0.00413f
C191 b0 a_6888_8456# 0.08103f
C192 pa14 pb10 0
C193 na2 a_8100_8456# 0
C194 n4 a_20100_21538# 0.06334f
C195 na9 nb11 0.01292f
C196 a_2330_8340# a_3306_8498# 0.41953f
C197 pb14 a_8100_8456# 0
C198 n3 a_20100_21538# 0.06989f
C199 p10 a_9954_23358# 0.514f
C200 pa4 v 1.64366f
C201 a_12909_20410# a_13894_23358# 0
C202 nb11 a_27349_23358# 0.36868f
C203 na11 rn 1.3631f
C204 pa10 a_9954_23358# 0.00117f
C205 a_11924_23358# pb12 0.36821f
C206 pa0 a_104_20410# 0.37647f
C207 n5 a_22424_20410# 0.22722f
C208 p9 a_9954_23358# 0.01804f
C209 v pb6 2.15303f
C210 v a_16514_20410# 1.80935f
C211 pb14 pa8 0.00477f
C212 v pb10 2.15299f
C213 nb14 na1 0.01106f
C214 a_16514_23358# na1 0.00428f
C215 pb4 a_5029_20410# 0.00413f
C216 p2 a_1720_21538# 0.06334f
C217 pa9 pa11 0.09141f
C218 v a_7984_20410# 1.91294f
C219 a_13554_8456# a_8100_8456# 2.40825f
C220 na7 nb6 1.81154f
C221 a_8100_8456# a_6888_8456# 0.73959f
C222 g4 a_6282_8456# 0.5746f
C223 a_29319_20410# a_30304_20410# 0.02905f
C224 v a_26364_23358# 2.02759f
C225 g4 mid 0.25673f
C226 na3 nb4 0.1569f
C227 a_9954_20410# a_10939_20410# 0.02905f
C228 pa3 pa1 0.03135f
C229 nb0 a_17145_21538# 0.001f
C230 nb9 n9 0.03003f
C231 pb13 a_13990_15860# 0.10513f
C232 n5 a_20454_23358# 0.00455f
C233 nb4 a_21439_20410# 0.00413f
C234 a_12948_8456# a_12342_8456# 0.26072f
C235 pa4 pb2 0.0886f
C236 a_6282_8456# a_11736_8456# 0
C237 pa11 pb10 1.81154f
C238 n8 nb9 0
C239 a_11924_20410# pb11 0.00413f
C240 mid a_11736_8456# 0.12445f
C241 pb5 a_6014_20410# 0.00413f
C242 g4 a_9312_8456# 0
C243 a_7630_21538# pb7 0.001f
C244 pb1 pa3 0.07776f
C245 a_10585_21538# pb10 0.001f
C246 pa14 a_6282_8456# 0
C247 a_30304_20410# nb14 0.01581f
C248 g20 g15 7.11139f
C249 v a_104_20410# 1.70172f
C250 pa7 a_6014_20410# 0
C251 a_10939_23358# a_10939_20410# 0.41634f
C252 a_12948_8456# sp 0
C253 a_9954_20410# a_8969_23358# 0.12679f
C254 n4 a_20454_23358# 0.514f
C255 n3 a_20454_23358# 0.01804f
C256 a_1720_21538# a_2074_23358# 0
C257 a_9312_8456# a_11736_8456# 0
C258 g4 a_11130_8456# 0.2297f
C259 a_12948_8456# a_2330_8340# 0.16341f
C260 g20 rp 0.13732f
C261 pa7 a_6999_23358# 0.00495f
C262 v a_6282_8456# 1.22859f
C263 a_2074_20410# pa2 0.37647f
C264 mid v 3.42362f
C265 a_12948_8456# a_3306_8498# 0.12855f
C266 pb8 a_8100_8456# 0
C267 nb3 nb5 0.05323f
C268 pa10 rp 1.30791f
C269 sn a_10524_8456# 0
C270 a_9600_21538# a_9954_23358# 0
C271 a_26364_20410# a_27349_23358# 0
C272 vb nb8 0
C273 a_30400_15860# v 2.80433f
C274 sn rn 2.39029f
C275 a_8706_8456# g20 0.19952f
C276 na13 nb11 0.11205f
C277 a_11130_8456# a_11736_8456# 0.0077f
C278 nb10 na11 1.81154f
C279 pb8 pa8 5.42409f
C280 v a_9312_8456# 0.80773f
C281 pa5 a_5029_20410# 0.37675f
C282 pa14 a_11130_8456# 1.21654f
C283 v a_8969_20410# 1.91472f
C284 v a_4044_23358# 2.02759f
C285 a_25379_20410# a_24394_23358# 0.12679f
C286 a_23409_23358# a_24040_21538# 0.20585f
C287 nb4 nb14 0
C288 p4 a_3059_20410# 0
C289 vb nb2 0
C290 na7 rn 1.3631f
C291 pa14 pb9 0
C292 v nb1 2.23337f
C293 a_9954_20410# a_10939_23358# 0
C294 na7 na5 0.09141f
C295 nb3 na6 0
C296 v na10 1.64645f
C297 a_12909_23358# a_13894_23358# 0.02326f
C298 a_7984_23358# v 2.02759f
C299 pa4 pa3 0.99157f
C300 v a_11130_8456# 0.68278f
C301 vb g20 2.28637f
C302 na10 na12 0.07295f
C303 a_29950_21538# nb13 0.001f
C304 a_23409_20410# a_24040_21538# 0.0013f
C305 nb9 nb8 0.95149f
C306 a_17499_23358# na2 0.00428f
C307 pa14 a_12909_20410# 0
C308 vb pa10 0.00156f
C309 pb0 pa1 1.77913f
C310 v pb9 2.05296f
C311 g4 a_12342_8456# 0.44749f
C312 a_21439_23358# v 2.02732f
C313 pa14 na0 0.00239f
C314 a_6645_21538# p7 0.06334f
C315 pa13 a_8100_8456# 0
C316 rs a_9918_8456# 0.53665f
C317 a_6014_20410# a_6999_23358# 0
C318 a_4675_21538# a_4044_20410# 0.0013f
C319 pb10 pa12 0.11083f
C320 v a_12909_20410# 1.91472f
C321 a_13990_15860# a_13894_20410# 0
C322 pb1 pb0 0.93321f
C323 g4 a_7494_8456# 0
C324 g4 sp 1.92755f
C325 n2 na2 0.02883f
C326 p6 a_6645_21538# 0.06989f
C327 vb nb11 0
C328 a_12342_8456# a_11736_8456# 0.02634f
C329 a_11130_8456# pa11 0
C330 nb8 na14 0
C331 v na0 1.22128f
C332 a_2330_8340# g4 0.24815f
C333 na1 rn 1.25249f
C334 n1 na2 0.00118f
C335 rp pa2 1.40178f
C336 a_7630_21538# a_6999_20410# 0.0013f
C337 pa14 a_12342_8456# 0
C338 p0 a_104_23358# 0.514f
C339 a_17499_23358# a_17499_20410# 0.41634f
C340 v a_24040_21538# 0.07832f
C341 nb0 na1 1.79273f
C342 nb4 nb6 0.05772f
C343 g4 a_3306_8498# 1.53845f
C344 a_9954_23358# pb11 0.00181f
C345 a_6014_23358# a_6645_21538# 0.20585f
C346 pa11 pb9 0.11205f
C347 a_30304_20410# a_29319_23358# 0.12679f
C348 nb3 a_20100_21538# 0.001f
C349 sp a_11736_8456# 0
C350 nb13 nb11 0.05487f
C351 a_27349_20410# na11 0.37675f
C352 p14 pb14 0.02934f
C353 pb0 a_1089_20410# 0.00413f
C354 a_18484_20410# nb1 0.00413f
C355 a_16514_23358# a_16514_20410# 0.41634f
C356 a_23409_23358# a_22424_23358# 0.02326f
C357 a_12342_8456# v 0.96773f
C358 pa14 pb5 0
C359 nb2 na14 0
C360 a_2330_8340# pa14 0.94442f
C361 pb14 p13 0
C362 a_3306_8498# a_11736_8456# 0
C363 pa14 pa7 0
C364 nb2 na2 5.42092f
C365 g20 na14 0
C366 n2 a_17499_20410# 0
C367 a_23409_20410# a_22424_23358# 0.12679f
C368 pa14 a_3306_8498# 0
C369 nb9 nb11 0.05487f
C370 n1 a_17499_20410# 0.28604f
C371 v a_7494_8456# 0.69412f
C372 a_20100_21538# a_20454_20410# 0.00308f
C373 sp v 14.6059f
C374 v pb5 2.05136f
C375 a_25379_23358# a_25379_20410# 0.41634f
C376 n9 a_24394_23358# 0.00455f
C377 v a_2705_21538# 0.07986f
C378 na3 nb1 0.07776f
C379 vb pa2 0.00269f
C380 v a_10939_20410# 1.91472f
C381 a_25025_21538# a_24394_23358# 0.20585f
C382 a_2330_8340# v 0.47552f
C383 pb12 a_8100_8456# 0
C384 n0 a_17499_20410# 0.22722f
C385 v pa7 2.05563f
C386 na3 a_11130_8456# 0
C387 pb14 pa10 0.00477f
C388 n8 a_24394_23358# 0.514f
C389 n7 a_24394_23358# 0.01804f
C390 v a_3306_8498# 1.30054f
C391 p1 pa2 0.00118f
C392 pa9 pb7 0.11205f
C393 nb4 a_21085_21538# 0.001f
C394 a_24040_21538# a_24394_20410# 0.00308f
C395 sn vinp 4.74478f
C396 nb11 na14 0
C397 g20 a_13554_8456# 0.24561f
C398 pa4 pa6 0.07295f
C399 g20 a_6888_8456# 0.14065f
C400 a_13990_15860# rn 0
C401 na13 nb12 1.81154f
C402 refmid sn 1.36418f
C403 nb5 na6 2.39425f
C404 a_21439_23358# a_21439_20410# 0.41634f
C405 a_18484_23358# a_19469_20410# 0.12679f
C406 sn b1 0.0038f
C407 pa6 pb6 5.42409f
C408 a_13990_15860# nb0 0
C409 p4 pb4 0.02934f
C410 g15 rs 0.69555f
C411 vinn sn 0.6125f
C412 vb nb3 0
C413 v a_22424_23358# 2.02759f
C414 b0 sn 0.00391f
C415 pa11 a_10939_20410# 0.37675f
C416 v a_8969_23358# 2.02732f
C417 pb7 pb6 0.95149f
C418 n11 na11 0.02889f
C419 pb13 a_11130_8456# 0
C420 a_10585_21538# a_10939_20410# 0.00308f
C421 a_2330_8340# pa11 0
C422 a_12948_8456# g4 0.26983f
C423 a_6282_8456# nb14 0
C424 a_2705_21538# pb2 0.001f
C425 pa14 a_12909_23358# 0.00428f
C426 v a_26995_21538# 0.07832f
C427 pb10 pb7 0
C428 n10 na11 0.00118f
C429 pb4 pa2 0.00356f
C430 pb7 a_7984_20410# 0.00413f
C431 rp pb11 1.92342f
C432 rs rp 3.84974f
C433 a_2330_8340# pb2 0
C434 a_11130_8456# pa12 0.00273f
C435 a_30400_15860# nb14 1.06698f
C436 nb4 na5 1.79112f
C437 a_9954_20410# v 1.91294f
C438 nb4 rn 2.61198f
C439 nb7 na10 0
C440 pa14 a_13894_23358# 0.00117f
C441 nb7 a_11130_8456# 0
C442 a_8706_8456# rs 0.18461f
C443 a_13554_8456# nb11 0
C444 a_12948_8456# a_11736_8456# 0.01185f
C445 a_4675_21538# a_4044_23358# 0.20585f
C446 pb9 pa12 0
C447 v a_12909_23358# 2.02732f
C448 pb13 a_12909_20410# 0.01281f
C449 a_20454_23358# a_20454_20410# 0.41634f
C450 sn a_8100_8456# 0
C451 na8 na10 0.07295f
C452 na8 a_11130_8456# 0.00273f
C453 p2 pa2 0.02883f
C454 a_25379_23358# n10 0.00455f
C455 pb0 a_104_20410# 0.01581f
C456 nb9 a_26364_20410# 0.00413f
C457 v a_6014_20410# 1.91294f
C458 v a_13894_23358# 1.98754f
C459 nb14 nb1 0.00182f
C460 a_16514_23358# nb1 0.00181f
C461 a_19469_23358# v 2.02732f
C462 na10 nb14 0.00477f
C463 nb9 a_26010_21538# 0.001f
C464 v a_10939_23358# 2.02732f
C465 nb14 a_11130_8456# 0.00455f
C466 a_9954_20410# pa11 0
C467 pb14 pa2 0.00501f
C468 a_3059_20410# a_2074_20410# 0.02905f
C469 a_12948_8456# v 0.61865f
C470 a_9954_20410# a_10585_21538# 0.0013f
C471 vb nb12 0
C472 g15 a_9918_8456# 0.31195f
C473 nb8 a_24394_23358# 0.36821f
C474 a_25379_23358# n9 0.514f
C475 v a_6999_23358# 2.02732f
C476 vb pb11 0
C477 vb rs 0.7836f
C478 pb3 pa1 0.00323f
C479 pb8 pa10 0.11083f
C480 a_25379_23358# a_25025_21538# 0
C481 n8 a_25379_23358# 0.01804f
C482 nb7 a_24040_21538# 0.001f
C483 p4 a_3690_21538# 0.06334f
C484 pa5 p5 0.02889f
C485 nb3 na14 0
C486 rp a_9918_8456# 0.65021f
C487 nb12 nb13 0.95149f
C488 pb3 pb1 0.00433f
C489 a_1089_23358# a_1720_21538# 0.20585f
C490 nb3 na2 0.07007f
C491 a_14525_21538# a_13894_23358# 0.20585f
C492 p4 pa5 0.00118f
C493 pb8 p8 0.02934f
C494 pa3 pb5 0.01268f
C495 a_10939_23358# pa11 0.00495f
C496 nb5 a_22424_20410# 0.00413f
C497 a_8706_8456# a_9918_8456# 4.1097f
C498 a_10585_21538# a_10939_23358# 0
C499 v a_735_21538# 0.07832f
C500 a_28965_21538# nb12 0.001f
C501 a_16514_20410# nb0 0.01581f
C502 a_2330_8340# pa3 0
C503 na0 nb14 0.78162f
C504 a_2074_23358# pa2 0.00117f
C505 a_23409_23358# a_23409_20410# 0.41634f
C506 a_2330_8340# pb13 0
C507 a_16514_23358# na0 0.00117f
C508 a_21439_20410# a_22424_23358# 0
C509 nb9 nb12 0
C510 p1 a_104_23358# 0.00455f
C511 pa13 p13 0.02889f
C512 pb8 p7 0
C513 a_10939_20410# pa12 0
C514 a_2330_8340# pa12 0.00201f
C515 a_11130_8456# nb6 0
C516 a_8100_8456# na1 0
C517 a_17499_23358# a_17145_21538# 0
C518 a_6999_20410# pb6 0.00413f
C519 pa13 p12 0.00118f
C520 nb3 a_13554_8456# 0
C521 na9 vb 0
C522 a_12342_8456# nb14 0
C523 vb nb5 0
C524 pa14 pa0 0.96058f
C525 g4 a_11736_8456# 0
C526 a_19469_23358# a_18484_20410# 0
C527 n14 a_30304_20410# 0.28607f
C528 a_22424_20410# na6 0.37647f
C529 nb5 a_20454_23358# 0.00181f
C530 vb a_9918_8456# 0.53498f
C531 nb8 na11 0
C532 a_6999_20410# a_7984_20410# 0.02905f
C533 p1 p0 0.05837f
C534 pa14 g4 0
C535 a_4044_20410# a_5029_23358# 0
C536 pb9 pb7 0.05487f
C537 nb12 na14 0.10801f
C538 pb12 a_12555_21538# 0.001f
C539 a_30304_20410# n13 0.22722f
C540 rs na14 0.00125f
C541 v pa0 1.31432f
C542 v a_23409_23358# 2.02732f
C543 nb4 na4 5.41111f
C544 pb3 a_4044_20410# 0.00413f
C545 a_23055_21538# a_22424_23358# 0.20585f
C546 a_2330_8340# nb14 0.00241f
C547 na3 a_19469_23358# 0.00495f
C548 a_12909_20410# a_13894_20410# 0.02905f
C549 nb7 a_22424_23358# 0.00181f
C550 n1 a_17145_21538# 0.06334f
C551 g4 v 9.07045f
C552 pb14 pb11 0
C553 pb3 pa4 2.38971f
C554 pb13 a_12909_23358# 0.36868f
C555 nb14 a_3306_8498# 0
C556 mid a_10524_8456# 0.04855f
C557 vb na6 0.00156f
C558 v a_23409_20410# 1.91472f
C559 a_6282_8456# a_10524_8456# 0
C560 na9 nb9 5.18114f
C561 p1 a_2074_20410# 0.22722f
C562 a_6282_8456# rn 0.18626f
C563 pb3 pb6 0
C564 na7 n7 0.02889f
C565 n0 a_17145_21538# 0.06989f
C566 g15 rp 0.17505f
C567 na7 n6 0.00118f
C568 nb12 a_13554_8456# 0
C569 a_30400_15860# rn 0.00241f
C570 v a_11736_8456# 0.72092f
C571 a_28334_20410# v 1.91294f
C572 a_28334_20410# na12 0.37647f
C573 a_13554_8456# rs 0.14337f
C574 rs a_6888_8456# 0.14979f
C575 pa14 v 1.76081f
C576 a_9312_8456# a_10524_8456# 0.03048f
C577 a_8706_8456# g15 3.19309f
C578 pb12 p12 0.02934f
C579 pa0 pb2 0.00356f
C580 a_21439_23358# a_21085_21538# 0
C581 pb12 p11 0
C582 a_10939_23358# pa12 0.00428f
C583 na9 na14 0
C584 p3 a_4044_20410# 0.22722f
C585 a_4044_20410# a_3059_23358# 0.12679f
C586 pb12 pa10 0.00592f
C587 nb5 na14 0
C588 nb1 rn 1.91437f
C589 nb11 na11 5.18114f
C590 a_8706_8456# rp 0.82673f
C591 a_23409_23358# a_24394_20410# 0.12679f
C592 pb5 pa6 2.39425f
C593 na10 rn 1.30791f
C594 pa4 a_3059_23358# 0.00428f
C595 pb5 pb7 0.05487f
C596 a_11130_8456# a_10524_8456# 0.01206f
C597 v na12 1.64645f
C598 pa4 p3 0.00118f
C599 nb1 nb0 0.93533f
C600 a_11130_8456# na5 0
C601 a_11130_8456# rn 0.12404f
C602 a_26364_23358# nb10 0.36821f
C603 a_2330_8340# pa6 0.00201f
C604 pa7 pa6 1.04629f
C605 a_11130_8456# nb0 0
C606 a_17499_23358# a_18130_21538# 0.20585f
C607 nb4 a_8100_8456# 0
C608 a_2330_8340# pb7 0
C609 a_11924_23358# a_12909_20410# 0.12679f
C610 pa14 pa11 0
C611 pa7 pb7 5.18114f
C612 a_23409_20410# a_24394_20410# 0.02905f
C613 a_30975_15860# na13 0.01305f
C614 na13 vb 0
C615 vb g15 0.73235f
C616 p2 a_2074_20410# 0.27955f
C617 a_20454_23358# a_20100_21538# 0
C618 a_21439_23358# na5 0.00495f
C619 pa14 pb2 0
C620 na9 a_13554_8456# 0
C621 a_7984_23358# a_6999_20410# 0
C622 na14 na6 0.00328f
C623 nb6 a_22424_23358# 0.36821f
C624 nb5 a_13554_8456# 0
C625 vb rp 0.1579f
C626 v a_14525_21538# 0.06867f
C627 na13 nb13 5.20657f
C628 v pa11 2.05555f
C629 a_10585_21538# v 0.07832f
C630 a_13554_8456# a_9918_8456# 0.26028f
C631 a_9918_8456# a_6888_8456# 0.27309f
C632 pb1 a_1720_21538# 0.001f
C633 a_18130_21538# n2 0.06334f
C634 na7 nb8 0.17247f
C635 n1 a_18130_21538# 0.06989f
C636 v pb2 2.98589f
C637 na0 rn 0.99408f
C638 vb a_8706_8456# 0.42339f
C639 na0 nb0 5.43615f
C640 v a_30304_23358# 1.99125f
C641 g20 sn 3.06528f
C642 a_17499_23358# na1 0.00495f
C643 a_5029_23358# a_4044_23358# 0.02326f
C644 v a_24394_20410# 1.91294f
C645 pa9 a_8100_8456# 0
C646 pa13 a_11924_20410# 0
C647 a_3059_20410# p2 0.22722f
C648 a_12342_8456# a_10524_8456# 0
C649 a_13554_8456# na6 0
C650 a_12342_8456# rn 0.19704f
C651 a_1720_21538# a_1089_20410# 0.0013f
C652 a_12909_23358# a_13894_20410# 0.12679f
C653 a_18484_20410# v 2.24237f
C654 a_11924_23358# a_10939_20410# 0
C655 pb8 a_8615_21538# 0.001f
C656 a_2074_20410# a_2074_23358# 0.2858f
C657 pa8 pa9 1.04629f
C658 pb4 rp 2.61198f
C659 a_21439_23358# a_22070_21538# 0.20585f
C660 a_6014_20410# pa6 0.37647f
C661 a_17499_23358# a_18484_23358# 0.02326f
C662 n1 na1 0.02889f
C663 a_23055_21538# a_23409_23358# 0
C664 a_26364_23358# a_25379_20410# 0
C665 a_26364_20410# na11 0
C666 sp a_10524_8456# 0
C667 a_13894_20410# a_13894_23358# 0.41634f
C668 a_26364_23358# a_27349_20410# 0.12679f
C669 pb10 a_8100_8456# 0
C670 sp rn 2.07255f
C671 nb7 a_23409_23358# 0.36868f
C672 na13 na14 0.98625f
C673 pa8 pb6 0.11083f
C674 na3 v 2.36802f
C675 a_2330_8340# rn 0.19784f
C676 n0 na1 0.00118f
C677 vb nb13 0
C678 n3 a_18484_23358# 0.00455f
C679 a_23055_21538# a_23409_20410# 0.00308f
C680 a_2330_8340# nb0 0
C681 na10 nb10 5.42409f
C682 v a_21439_20410# 1.91472f
C683 pa13 pb11 0.11205f
C684 na8 a_23409_23358# 0.00428f
C685 a_6282_8456# vinp 0.00492f
C686 a_30975_15860# nb13 0.05353f
C687 pb7 a_6999_23358# 0.36868f
C688 nb7 a_23409_20410# 0.01281f
C689 a_3306_8498# a_10524_8456# 0
C690 pa14 pa3 0
C691 a_11130_8456# nb10 0
C692 rp na14 0
C693 pa8 pb10 0.00592f
C694 pa14 pb13 2.36869f
C695 a_3306_8498# rn 0.16156f
C696 pa8 a_7984_20410# 0.37647f
C697 a_3059_20410# a_3690_21538# 0.0013f
C698 a_6282_8456# b1 0.1921f
C699 refmid mid 1.72901f
C700 refmid a_6282_8456# 0.00894f
C701 mid b1 0.01357f
C702 a_6282_8456# vinn 0.01742f
C703 a_25379_23358# a_26364_20410# 0.12679f
C704 n2 a_18484_23358# 0.5075f
C705 a_3059_23358# a_4044_23358# 0.02326f
C706 b0 mid 0.30159f
C707 na8 a_23409_20410# 0
C708 p3 a_4044_23358# 0.01804f
C709 a_29319_20410# a_28334_20410# 0.02905f
C710 pb0 a_735_21538# 0.001f
C711 b0 a_6282_8456# 0.28941f
C712 a_3059_20410# a_2074_23358# 0.12679f
C713 pa14 pa12 0.0752f
C714 nb2 na1 0.16435f
C715 pb14 rp 1.92745f
C716 n1 a_18484_23358# 0.01804f
C717 nb1 na4 0
C718 a_11570_21538# a_10939_20410# 0.0013f
C719 pa3 v 2.36872f
C720 vb nb9 0
C721 a_25379_23358# a_26010_21538# 0.20585f
C722 pb4 vb 0
C723 pb13 v 2.11947f
C724 g4 nb14 0
C725 pa7 a_6999_20410# 0.37675f
C726 a_4044_20410# a_5029_20410# 0.02905f
C727 pb12 a_11924_20410# 0.01581f
C728 a_11130_8456# na4 0.00273f
C729 g15 a_13554_8456# 0.12361f
C730 p8 a_7630_21538# 0.06334f
C731 na9 a_24394_23358# 0.00428f
C732 g15 a_6888_8456# 0.13964f
C733 a_11924_23358# a_12909_23358# 0.02326f
C734 a_9312_8456# b1 0.14131f
C735 refmid a_9312_8456# 0.00929f
C736 pb14 a_14565_15860# 0.02192f
C737 v pa12 1.64645f
C738 nb12 na11 0.17247f
C739 b0 a_9312_8456# 0.19924f
C740 a_29319_20410# v 1.91472f
C741 v a_23055_21538# 0.07832f
C742 nb7 v 2.05296f
C743 a_13554_8456# rp 0.02163f
C744 a_11130_8456# vinp 0
C745 rp a_6888_8456# 0.10513f
C746 pb5 a_5029_23358# 0.36868f
C747 a_1089_23358# pa2 0.00428f
C748 a_7630_21538# p7 0.06989f
C749 nb2 a_18484_23358# 0.36821f
C750 mid a_8100_8456# 0.00132f
C751 a_6282_8456# a_8100_8456# 0.79762f
C752 vb na14 0.25756f
C753 pa14 nb14 0
C754 a_29950_21538# a_30304_20410# 0.00308f
C755 a_30975_15860# na14 0.01341f
C756 a_11924_23358# a_10939_23358# 0.02326f
C757 refmid a_11130_8456# 0.00441f
C758 n11 a_26364_23358# 0.00455f
C759 na8 v 1.64645f
C760 vinn a_11130_8456# 0
C761 a_8706_8456# a_13554_8456# 0.2021f
C762 a_11130_8456# b1 0.30581f
C763 nb4 n4 0.02934f
C764 a_4675_21538# v 0.07832f
C765 pb3 pb5 0.05323f
C766 a_8706_8456# a_6888_8456# 0.21919f
C767 pa5 rp 1.61228f
C768 pb13 pa11 0.01292f
C769 b0 a_11130_8456# 0.09111f
C770 nb4 n3 0
C771 vb na2 0.0033f
C772 na3 a_18484_20410# 0
C773 p1 p2 0.05837f
C774 pb0 pa0 5.43615f
C775 vb pb14 0.00422f
C776 n10 a_26364_23358# 0.514f
C777 pb3 a_2330_8340# 0
C778 pb12 pb11 1.02201f
C779 pa3 pb2 1.77757f
C780 a_28334_20410# a_28334_23358# 0.41634f
C781 a_13540_21538# a_12909_20410# 0.0013f
C782 pa11 pa12 1.01092f
C783 v nb14 2.235f
C784 nb13 na14 2.36869f
C785 a_9312_8456# a_8100_8456# 0
C786 a_16514_23358# v 1.95906f
C787 nb14 na12 0.0107f
C788 na10 a_25379_20410# 0
C789 a_26364_23358# n9 0.01804f
C790 a_12948_8456# rn 0.21423f
C791 a_22070_21538# a_22424_23358# 0
C792 a_23409_20410# nb6 0.00413f
C793 nb1 a_8100_8456# 0
C794 a_29319_20410# a_30304_23358# 0
C795 vb a_13554_8456# 0.93149f
C796 vb a_6888_8456# 0.37263f
C797 v a_28334_23358# 2.02759f
C798 a_11130_8456# a_8100_8456# 0.17453f
C799 a_6014_20410# a_6999_20410# 0.02905f
C800 na9 na11 0.09141f
C801 nb9 na14 0
C802 na12 a_28334_23358# 0.00117f
C803 a_27349_23358# na11 0.00495f
C804 pa14 pb0 0.16989f
C805 nb7 a_24394_20410# 0.00413f
C806 a_11570_21538# a_10939_23358# 0.20585f
C807 pb8 rp 2.07524f
C808 pb4 pb14 0
C809 pb9 a_8100_8456# 0
C810 vb pa5 0
C811 a_12342_8456# vinp 0.00219f
C812 a_2705_21538# a_3059_23358# 0
C813 pa8 a_7984_23358# 0.00117f
C814 p3 a_2705_21538# 0.06334f
C815 a_6999_23358# a_6999_20410# 0.41634f
C816 nb4 nb2 0.007f
C817 pa14 pa6 0.00328f
C818 na8 a_24394_20410# 0.37647f
C819 a_19469_23358# a_19469_20410# 0.41634f
C820 p1 a_2074_23358# 0.01804f
C821 a_17499_23358# a_16514_20410# 0
C822 pa14 a_13894_20410# 0.376f
C823 refmid a_12342_8456# 0.01029f
C824 pa14 pb7 0
C825 a_12342_8456# vinn 0.00374f
C826 a_12342_8456# b1 0.08835f
C827 nb14 a_30304_23358# 0.3723f
C828 pb0 v 1.99787f
C829 b0 a_12342_8456# 0.00991f
C830 pa8 pb9 0.08313f
C831 na9 a_25379_23358# 0.00495f
C832 a_5029_23358# a_6014_20410# 0.12679f
C833 v nb6 2.15299f
C834 sp vinp 0.51168f
C835 a_26995_21538# nb10 0.001f
C836 rs sn 0.03088f
C837 nb9 a_13554_8456# 0
C838 v pa6 1.64718f
C839 refmid a_7494_8456# 0.00941f
C840 na0 a_8100_8456# 0
C841 na14 na2 0.00328f
C842 a_2330_8340# vinp 0
C843 v a_13894_20410# 1.89818f
C844 pb14 na14 0
C845 a_7494_8456# b1 0.17258f
C846 sp b1 0.00101f
C847 refmid sp 0.92272f
C848 v pb7 2.05302f
C849 sp vinn 3.29795f
C850 b0 a_7494_8456# 0.23934f
C851 b0 sp 0.00118f
C852 a_2330_8340# refmid 0.0039f
C853 nb3 na1 0.00323f
C854 a_5029_20410# a_4044_23358# 0.12679f
C855 a_2330_8340# b1 0.1642f
C856 a_3306_8498# vinp 0.01022f
C857 a_2330_8340# vinn 0
C858 a_2330_8340# b0 0.15945f
C859 pb8 vb 0
C860 pb4 pa5 1.79112f
C861 n1 a_16514_20410# 0
C862 refmid a_3306_8498# 0.03796f
C863 vinn a_3306_8498# 0.10586f
C864 a_3306_8498# b1 0.22723f
C865 na10 n10 0.02883f
C866 a_12342_8456# a_8100_8456# 0.38889f
C867 a_28334_20410# a_29319_23358# 0
C868 pb13 pa12 0.08313f
C869 b0 a_3306_8498# 0.2038f
C870 n0 a_16514_20410# 0.28604f
C871 a_13554_8456# na14 0
C872 pa13 rp 1.23043f
C873 pb0 pb2 0.007f
C874 na3 nb14 0
C875 na14 a_6888_8456# 0
C876 a_1089_23358# a_104_23358# 0.02326f
C877 g4 a_10524_8456# 0
C878 g4 rn 0.27182f
C879 na10 n9 0.00118f
C880 a_13554_8456# na2 0
C881 a_13894_20410# a_14525_21538# 0.0013f
C882 p2 a_2074_23358# 0.5075f
C883 a_7494_8456# a_8100_8456# 0.01271f
C884 pb14 a_13554_8456# 0
C885 pa9 pa10 1.01092f
C886 sp a_8100_8456# 0
C887 nb3 a_18484_23358# 0.00181f
C888 pb14 a_6888_8456# 0
C889 na2 a_17499_20410# 0
C890 p9 pa9 0.02889f
C891 pa1 pa2 0.99157f
C892 pa13 a_14565_15860# 0.01305f
C893 v a_21085_21538# 0.07832f
C894 a_2330_8340# a_8100_8456# 0.30146f
C895 a_29319_23358# v 2.02732f
C896 pa7 a_8100_8456# 0
C897 a_13540_21538# a_12909_23358# 0.20585f
C898 sn a_9918_8456# 0
C899 a_10524_8456# a_11736_8456# 0.03049f
C900 pb14 pa5 0
C901 na13 na11 0.09141f
C902 a_3306_8498# a_8100_8456# 0.22264f
C903 a_1089_23358# p0 0.01804f
C904 pa8 pb5 0
C905 a_19469_23358# na4 0.00428f
C906 pa14 rn 0
C907 a_11924_23358# v 2.02759f
C908 p8 pa9 0.00118f
C909 na8 nb7 2.39425f
C910 pb1 pa2 2.37723f
C911 a_2330_8340# pa8 0.00201f
C912 a_19115_21538# a_18484_23358# 0.20585f
C913 pa8 pa7 1.01092f
C914 a_13554_8456# a_6888_8456# 0.13357f
C915 a_13540_21538# a_13894_23358# 0
C916 p10 pb10 0.02934f
C917 pa14 nb0 0
C918 pa10 pb10 5.42409f
C919 a_26995_21538# a_27349_20410# 0.00308f
C920 na9 na7 0.09141f
C921 a_21439_23358# n6 0.00455f
C922 p9 pb10 0
C923 na7 nb5 0.11205f
C924 pa13 vb 0
C925 nb7 nb14 0
C926 a_27980_21538# a_28334_20410# 0.00308f
C927 p9 a_7984_20410# 0
C928 v a_10524_8456# 0.45176f
C929 v rn 4.29959f
C930 a_17499_23358# nb1 0.36868f
C931 a_12948_8456# vinp 0.0621f
C932 v na5 2.05251f
C933 a_1089_23358# a_2074_20410# 0.12679f
C934 na12 rn 1.30791f
C935 v nb0 1.87713f
C936 na8 nb14 0.00477f
C937 a_12948_8456# b1 2.96184f
C938 n5 a_21439_23358# 0.514f
C939 a_12948_8456# refmid 0.0197f
C940 a_1089_20410# pa2 0
C941 pb12 rp 2.07524f
C942 a_12948_8456# vinn 0.05971f
C943 n8 a_24040_21538# 0.06334f
C944 p8 a_7984_20410# 0.28604f
C945 a_29319_20410# a_28334_23358# 0.12679f
C946 nb9 a_24394_23358# 0.00181f
C947 pb8 pb14 0
C948 n7 a_24040_21538# 0.06989f
C949 a_12948_8456# b0 0.14042f
C950 a_29319_23358# a_30304_23358# 0.02326f
C951 pb5 a_5029_20410# 0.01281f
C952 p5 a_4044_20410# 0
C953 nb3 nb4 1.01031f
C954 a_27980_21538# v 0.07832f
C955 pb0 pa3 0
C956 a_26364_23358# nb11 0.00181f
C957 v a_11570_21538# 0.07832f
C958 v a_6999_20410# 1.91472f
C959 p4 a_4044_20410# 0.28604f
C960 na7 na6 1.04629f
C961 p7 a_7984_20410# 0.22722f
C962 p6 pb6 0.02934f
C963 p5 pb6 0
C964 vb na11 0
C965 n1 nb1 0.03003f
C966 a_21439_23358# n4 0.01804f
C967 mid g20 1.3997f
C968 p4 pa4 0.02883f
C969 g20 a_6282_8456# 0.20378f
C970 pb13 a_13894_20410# 0.00413f
C971 v a_19469_20410# 1.91545f
C972 a_6014_23358# pb6 0.36821f
C973 nb8 na10 0.11083f
C974 nb4 a_20454_20410# 0.01581f
C975 n0 nb1 0
C976 nb8 a_11130_8456# 0
C977 a_23055_21538# nb6 0.001f
C978 pb3 pa14 0
C979 pa4 pa2 0.02209f
C980 a_12948_8456# a_8100_8456# 0.18911f
C981 nb7 nb6 0.95149f
C982 nb13 na11 0.01292f
C983 a_22070_21538# v 0.07832f
C984 v a_5029_23358# 2.02732f
C985 vb pb12 0
C986 n11 a_26995_21538# 0.06334f
C987 g15 sn 2.51384f
C988 g20 a_9312_8456# 0.10573f
C989 a_12555_21538# a_12909_20410# 0.00308f
C990 n10 a_26995_21538# 0.06989f
C991 na8 nb6 0.11083f
C992 a_21085_21538# a_21439_20410# 0.00308f
C993 nb2 nb1 1.0101f
C994 pa8 a_6999_23358# 0.00428f
C995 pb3 v 2.14836f
C996 a_8969_20410# pa10 0
C997 p10 a_8969_20410# 0
C998 rp sn 0.70893f
C999 nb2 a_11130_8456# 0
C1000 pa1 a_104_23358# 0.00428f
C1001 nb9 na11 0.11205f
C1002 pa13 pb14 0.17135f
C1003 nb14 nb6 0
C1004 p9 a_8969_20410# 0.28604f
C1005 g20 a_11130_8456# 0.2005f
C1006 p14 a_12909_20410# 0
C1007 n7 a_22424_23358# 0.00455f
C1008 g4 vinp 0.05905f
C1009 a_8706_8456# sn 0
C1010 a_5660_21538# pb5 0.001f
C1011 n6 a_22424_23358# 0.514f
C1012 na3 rn 1.76431f
C1013 n0 na0 0.02883f
C1014 na3 na5 0.03135f
C1015 a_11130_8456# pa10 0.00182f
C1016 a_12909_20410# p13 0.28604f
C1017 p8 a_8969_20410# 0.22722f
C1018 p9 a_7984_23358# 0.00455f
C1019 v nb10 2.15299f
C1020 a_6014_20410# a_5029_20410# 0.02905f
C1021 na3 nb0 0
C1022 pb1 a_104_23358# 0.00181f
C1023 refmid g4 0.32959f
C1024 na12 nb10 0.11083f
C1025 g4 b1 0.17539f
C1026 a_11924_23358# pb13 0.00181f
C1027 g4 vinn 0.07648f
C1028 na5 a_21439_20410# 0.37675f
C1029 b0 g4 0.08032f
C1030 pa13 a_13554_8456# 0
C1031 p0 pa1 0.00118f
C1032 a_29319_20410# a_29319_23358# 0.41634f
C1033 pa10 pb9 2.39425f
C1034 nb9 a_25379_23358# 0.36868f
C1035 a_18484_20410# a_19469_20410# 0.02905f
C1036 na14 na11 0
C1037 a_12909_20410# p12 0.22722f
C1038 a_26364_23358# a_26364_20410# 0.41634f
C1039 p8 a_7984_23358# 0.514f
C1040 p9 pb9 0.03003f
C1041 pb3 pb2 0.93174f
C1042 a_11924_23358# pa12 0.00117f
C1043 nb2 na0 0.00592f
C1044 n5 a_22424_23358# 0.01804f
C1045 a_26364_23358# a_26010_21538# 0
C1046 na10 nb11 0.08313f
C1047 v a_3059_23358# 2.02732f
C1048 p3 v 0.52537f
C1049 na7 a_22424_20410# 0
C1050 refmid a_11736_8456# 0.02537f
C1051 v na4 1.64248f
C1052 a_11736_8456# b1 0.143f
C1053 vb sn 0.47371f
C1054 pb1 p0 0
C1055 pa9 pb11 0.01292f
C1056 b0 a_11736_8456# 0.21259f
C1057 a_104_23358# a_1089_20410# 0.12679f
C1058 p8 pb9 0
C1059 pa14 b1 0
C1060 a_7984_23358# p7 0.01804f
C1061 pa14 b0 0
C1062 na3 a_19469_20410# 0.37675f
C1063 v a_13540_21538# 0.07832f
C1064 nb5 nb4 0.9509f
C1065 g4 a_8100_8456# 0.45553f
C1066 v vinp 0.3215f
C1067 a_28334_20410# n13 0
C1068 p5 a_4044_23358# 0.00455f
C1069 nb7 rn 1.92342f
C1070 pb14 pb12 0.05711f
C1071 a_13554_8456# na11 0
C1072 g20 a_12342_8456# 0.2024f
C1073 a_1089_23358# p1 0.514f
C1074 nb7 na5 0.01292f
C1075 p4 a_4044_23358# 0.514f
C1076 refmid v 2.95659f
C1077 pb7 pa6 0.08313f
C1078 v b1 2.5776f
C1079 vb na7 0
C1080 a_28334_20410# a_27349_20410# 0.02905f
C1081 v vinn 0.37517f
C1082 b0 v 3.33229f
C1083 p0 a_1089_20410# 0.22722f
C1084 n14 v 0.36803f
C1085 pb1 a_2074_20410# 0.00413f
C1086 pb10 pb11 0.95149f
C1087 na8 rn 1.30791f
C1088 a_22070_21538# a_21439_20410# 0.0013f
C1089 a_29319_23358# a_28334_23358# 0.02326f
C1090 a_11736_8456# a_8100_8456# 0
C1091 a_9600_21538# a_8969_20410# 0.0013f
C1092 g20 a_7494_8456# 0.01095f
C1093 a_2330_8340# nb2 0
C1094 sp g20 3.52797f
C1095 v n13 0.52489f
C1096 a_28334_20410# n12 0.28604f
C1097 a_10939_20410# p12 0
C1098 pa14 a_8100_8456# 0.0013f
C1099 a_14565_15860# na1 0
C1100 nb14 rn 1.92745f
C1101 a_5660_21538# a_6014_20410# 0.00308f
C1102 a_2330_8340# g20 0.25118f
C1103 nb4 na6 0.11083f
C1104 a_10939_20410# p11 0.28604f
C1105 v a_25379_20410# 1.91472f
C1106 nb14 na5 0
C1107 nb14 nb0 0.96495f
C1108 v a_27349_20410# 1.91472f
C1109 a_16514_23358# nb0 0.36821f
C1110 p10 a_10939_20410# 0.22722f
C1111 a_12555_21538# a_12909_23358# 0
C1112 a_27349_20410# na12 0
C1113 g20 a_3306_8498# 0.13557f
C1114 a_17145_21538# a_17499_20410# 0.00308f
C1115 a_2330_8340# pa10 0.00201f
C1116 a_2074_20410# a_1089_20410# 0.02905f
C1117 pa14 pa8 0.00328f
C1118 a_19469_23358# n4 0.00455f
C1119 a_19469_23358# n3 0.514f
C1120 v a_8100_8456# 1.05963f
C1121 nb9 na7 0.01292f
C1122 a_9600_21538# pb9 0.001f
C1123 pb3 pa3 5.18114f
C1124 v n12 0.52489f
C1125 a_8615_21538# a_7984_20410# 0.0013f
C1126 nb3 nb1 0.00433f
C1127 vb na1 0
C1128 na12 n12 0.02883f
C1129 na10 a_26364_20410# 0.37647f
C1130 n14 a_30304_23358# 0.514f
C1131 nb3 a_11130_8456# 0
C1132 a_1089_23358# p2 0.00455f
C1133 p14 a_12909_23358# 0.00455f
C1134 pa8 v 1.64972f
C1135 a_19469_23358# n2 0.01804f
C1136 p10 a_8969_23358# 0.00455f
C1137 a_8969_23358# pa10 0.00428f
C1138 a_27980_21538# a_28334_23358# 0
C1139 na3 na4 0.99157f
C1140 n13 a_30304_23358# 0.01804f
C1141 a_4675_21538# a_5029_23358# 0
C1142 a_12909_23358# p13 0.514f
C1143 a_6282_8456# rs 0.16041f
C1144 pa1 rp 1.25249f
C1145 n11 a_28334_20410# 0.22722f
C1146 mid rs 0.00292f
C1147 p9 a_8969_23358# 0.514f
C1148 a_13990_15860# rp 0.00241f
C1149 p14 a_13894_23358# 0.514f
C1150 n7 a_23409_23358# 0.514f
C1151 a_9954_20410# p11 0
C1152 pa11 a_8100_8456# 0
C1153 a_26364_23358# a_27349_23358# 0.02326f
C1154 n8 a_23409_23358# 0.00455f
C1155 na7 na14 0
C1156 v a_1720_21538# 0.07832f
C1157 pa7 p7 0.02889f
C1158 nb12 a_30400_15860# 0
C1159 rn nb6 2.07524f
C1160 a_104_23358# a_104_20410# 0.44808f
C1161 a_12909_23358# p12 0.01804f
C1162 na5 nb6 0.17247f
C1163 a_25379_20410# a_24394_20410# 0.02905f
C1164 p5 pb5 0.03003f
C1165 p10 a_9954_20410# 0.28604f
C1166 a_23409_23358# n6 0.01804f
C1167 a_9954_20410# pa10 0.37647f
C1168 p8 a_8969_23358# 0.01804f
C1169 p13 a_13894_23358# 0.01804f
C1170 a_13554_8456# sn 0
C1171 sn a_6888_8456# 0
C1172 a_9954_20410# p9 0.22722f
C1173 pb1 rp 1.91437f
C1174 n8 a_23409_20410# 0
C1175 pb10 a_9954_23358# 0.36821f
C1176 p6 pa7 0.00118f
C1177 n7 a_23409_20410# 0.28604f
C1178 a_13990_15860# a_14565_15860# 2.34711f
C1179 pa3 a_3059_23358# 0.00495f
C1180 p4 pb5 0
C1181 nb7 nb10 0
C1182 pa3 p3 0.02889f
C1183 a_21439_23358# a_20454_20410# 0
C1184 rs a_9312_8456# 0.00398f
C1185 a_23409_20410# n6 0.22722f
C1186 n11 v 0.52489f
C1187 v a_5029_20410# 1.91472f
C1188 a_10939_23358# p12 0.00455f
C1189 n11 na12 0.00118f
C1190 a_11924_20410# a_12909_20410# 0.02905f
C1191 a_6014_23358# pa7 0.00428f
C1192 na8 nb10 0.00592f
C1193 v n10 0.52489f
C1194 a_10939_23358# p11 0.514f
C1195 p0 a_104_20410# 0.28604f
C1196 nb12 na10 0.00592f
C1197 a_1089_23358# a_2074_23358# 0.02326f
C1198 pb13 a_13540_21538# 0.001f
C1199 a_12948_8456# g20 0.2285f
C1200 a_3059_20410# a_4044_20410# 0.02905f
C1201 a_2330_8340# pa2 0.00189f
C1202 na7 a_13554_8456# 0
C1203 p10 a_10939_23358# 0.01804f
C1204 nb13 a_30304_20410# 0.00413f
C1205 pb7 a_6999_20410# 0.01281f
C1206 a_11130_8456# pb11 0
C1207 rs a_11130_8456# 0.01479f
C1208 vb pa1 0
C1209 nb14 nb10 0
C1210 a_3059_20410# pa4 0
C1211 v n9 0.52489f
C1212 na14 na1 0.00137f
C1213 v a_25025_21538# 0.07832f
C1214 pb9 pb11 0.05487f
C1215 a_18130_21538# a_17499_20410# 0.0013f
C1216 a_25379_23358# a_24394_23358# 0.02326f
C1217 a_8615_21538# a_8969_20410# 0.00308f
C1218 na2 na1 0.9951f
C1219 a_6282_8456# a_9918_8456# 0.25184f
C1220 mid a_9918_8456# 0.00184f
C1221 p1 pa1 0.02889f
C1222 n8 v 0.52489f
C1223 na3 a_8100_8456# 0
C1224 v n7 0.52489f
C1225 vb pb1 0
C1226 v n6 0.52489f
C1227 a_5029_23358# pa6 0.00428f
C1228 pa9 rp 1.3631f
C1229 nb14 na4 0.00477f
C1230 pa13 pb12 1.81154f
C1231 a_7984_23358# a_8615_21538# 0.20585f
C1232 vb nb4 0
C1233 a_29319_20410# n14 0
C1234 a_6014_20410# p7 0
C1235 p8 a_6999_23358# 0.00455f
C1236 p1 pb1 0.03003f
C1237 a_9600_21538# a_8969_23358# 0.20585f
C1238 nb4 a_20454_23358# 0.36821f
C1239 pb3 pa6 0
C1240 a_9312_8456# a_9918_8456# 0.03011f
C1241 a_29319_20410# n13 0.28604f
C1242 a_13554_8456# na1 0
C1243 p6 a_6014_20410# 0.28604f
C1244 pa4 rp 2.05925f
C1245 n5 v 0.52489f
C1246 a_11924_20410# a_10939_20410# 0.02905f
C1247 na9 na10 1.01092f
C1248 p5 a_6014_20410# 0.22722f
C1249 a_18484_23358# na2 0.00117f
C1250 p7 a_6999_23358# 0.514f
C1251 pb13 a_8100_8456# 0
C1252 rp pb6 2.07524f
C1253 na9 a_11130_8456# 0
C1254 a_30304_20410# na14 0.376f
C1255 a_9954_20410# a_9600_21538# 0.00308f
C1256 na1 a_17499_20410# 0.37675f
C1257 a_6014_23358# a_6014_20410# 0.41634f
C1258 nb5 a_11130_8456# 0
C1259 na5 rn 1.61228f
C1260 rp pb10 2.07524f
C1261 nb14 vinn 0
C1262 a_17499_23358# v 2.02804f
C1263 a_8100_8456# pa12 0
C1264 nb0 rn 1.88363f
C1265 a_11130_8456# a_9918_8456# 0.36302f
C1266 a_5660_21538# v 0.07832f
C1267 a_8969_20410# a_9954_23358# 0
C1268 n9 a_24394_20410# 0
C1269 a_12342_8456# rs 0.15418f
C1270 p6 a_6999_23358# 0.01804f
C1271 n14 nb14 0.03152f
C1272 a_11924_23358# a_11570_21538# 0
C1273 p1 a_1089_20410# 0.28604f
C1274 a_26364_20410# a_26995_21538# 0.0013f
C1275 pb4 pb1 0
C1276 a_25025_21538# a_24394_20410# 0.0013f
C1277 a_6645_21538# pb6 0.001f
C1278 nb5 a_21439_23358# 0.36868f
C1279 a_29319_20410# n12 0.22722f
C1280 n4 v 0.52489f
C1281 n3 v 0.52537f
C1282 a_6014_23358# a_6999_23358# 0.02326f
C1283 n13 nb14 0
C1284 n8 a_24394_20410# 0.28604f
C1285 n7 a_24394_20410# 0.22722f
C1286 vb pa9 0
C1287 a_7494_8456# rs 0.00383f
C1288 sp rs 0.68499f
C1289 a_12555_21538# v 0.07832f
C1290 g4 g20 2.95178f
C1291 na4 nb6 0.00592f
C1292 p14 pa14 0.02883f
C1293 a_18484_23358# a_17499_20410# 0
C1294 pb14 pa1 0.01106f
C1295 pb11 a_10939_20410# 0.01281f
C1296 a_2330_8340# pb11 0
C1297 a_2330_8340# rs 0.68736f
C1298 v n2 0.59055f
C1299 a_30304_20410# a_30935_21538# 0.0013f
C1300 pb14 a_13990_15860# 1.06698f
C1301 vb pa4 0.00156f
C1302 a_11130_8456# na6 0.00273f
C1303 n1 v 0.52516f
C1304 vb pb6 0
C1305 nb14 a_8100_8456# 0
C1306 n13 a_28334_23358# 0.00455f
C1307 nb8 v 2.15299f
C1308 rs a_3306_8498# 0.35091f
C1309 pa14 p13 0.00118f
C1310 g15 a_6282_8456# 0.2019f
C1311 nb4 na14 0
C1312 mid g15 0.83988f
C1313 a_21439_23358# na6 0.00428f
C1314 a_27349_20410# a_28334_23358# 0
C1315 nb3 a_19469_23358# 0.36868f
C1316 a_13540_21538# a_13894_20410# 0.00308f
C1317 pb14 pb1 0.00182f
C1318 a_11924_20410# a_12909_23358# 0
C1319 g20 a_11736_8456# 0.04288f
C1320 vb pb10 0
C1321 n0 v 0.50778f
C1322 p14 v 0.4267f
C1323 nb4 na2 0.00356f
C1324 a_3059_20410# a_4044_23358# 0
C1325 a_29950_21538# v 0.07832f
C1326 na13 a_30400_15860# 0.09041f
C1327 v p13 0.52489f
C1328 a_6282_8456# rp 0.14738f
C1329 mid rp 0.00183f
C1330 n12 a_28334_23358# 0.514f
C1331 a_12342_8456# a_9918_8456# 0.49646f
C1332 p2 a_1089_20410# 0
C1333 pb4 a_4044_20410# 0.01581f
C1334 nb2 v 2.73255f
C1335 pa14 pa10 0.00328f
C1336 a_21439_20410# n6 0
C1337 g15 a_9312_8456# 0.02411f
C1338 a_17499_23358# a_18484_20410# 0.12679f
C1339 a_11924_20410# a_10939_23358# 0.12679f
C1340 v p12 0.52489f
C1341 a_19469_23358# a_19115_21538# 0
C1342 a_19469_23358# a_20454_20410# 0.12679f
C1343 a_8706_8456# a_6282_8456# 0.28878f
C1344 g20 v 42.3978f
C1345 mid a_8706_8456# 0.00132f
C1346 v p11 0.52489f
C1347 pb4 pa4 5.41111f
C1348 pb4 pb6 0.05772f
C1349 a_4675_21538# a_5029_20410# 0.00308f
C1350 n3 a_18484_20410# 0
C1351 a_28334_20410# nb11 0.00413f
C1352 sp a_9918_8456# 0
C1353 p14 a_14525_21538# 0.06989f
C1354 a_9312_8456# rp 0
C1355 p10 v 0.52489f
C1356 v pa10 1.64645f
C1357 n5 a_21439_20410# 0.28604f
C1358 a_2330_8340# a_9918_8456# 0.17538f
C1359 p9 v 0.52489f
C1360 g15 a_11130_8456# 0.19994f
C1361 nb10 rn 2.07524f
C1362 a_8100_8456# nb6 0
C1363 a_8615_21538# a_8969_23358# 0
C1364 nb8 a_24394_20410# 0.01581f
C1365 a_8706_8456# a_9312_8456# 0.00446f
C1366 a_18484_20410# n2 0.27955f
C1367 n7 a_23055_21538# 0.06334f
C1368 a_3306_8498# a_9918_8456# 0.15066f
C1369 pb14 pa9 0
C1370 n1 a_18484_20410# 0.22722f
C1371 pb7 a_8100_8456# 0
C1372 nb7 n7 0.03003f
C1373 p8 v 0.52489f
C1374 a_2705_21538# a_2074_20410# 0.0013f
C1375 a_23055_21538# n6 0.06989f
C1376 a_11130_8456# rp 0.03153f
C1377 pa0 pa2 0.02209f
C1378 p1 a_104_20410# 0
C1379 a_9954_23358# a_10939_20410# 0.12679f
C1380 vb a_6282_8456# 0.35162f
C1381 na3 n3 0.02889f
C1382 a_29950_21538# a_30304_23358# 0
C1383 mid vb 0.8624f
C1384 v nb11 2.05296f
C1385 a_10939_23358# pb11 0.36868f
C1386 nb7 n6 0
C1387 pa11 p11 0.02889f
C1388 n4 a_21439_20410# 0.22722f
C1389 a_1089_20410# a_2074_23358# 0
C1390 pa8 pa6 0.07295f
C1391 a_10585_21538# p11 0.06334f
C1392 n11 a_28334_23358# 0.01804f
C1393 a_12948_8456# rs 0.59135f
C1394 nb11 na12 2.39425f
C1395 na8 n8 0.02883f
C1396 n14 a_29319_23358# 0.00455f
C1397 na8 n7 0.00118f
C1398 na4 rn 2.05925f
C1399 pb14 pa4 0.00477f
C1400 p10 pa11 0.00118f
C1401 pa8 pb7 2.39425f
C1402 p10 a_10585_21538# 0.06989f
C1403 pa11 pa10 1.04629f
C1404 rp pb9 1.92342f
C1405 na5 na4 1.03039f
C1406 a_8706_8456# a_11130_8456# 0.35931f
C1407 a_30975_15860# a_30400_15860# 2.34711f
C1408 a_26995_21538# a_27349_23358# 0
C1409 na3 n2 0.00118f
C1410 pb14 pb6 0
C1411 v p7 0.52489f
C1412 a_29319_23358# n13 0.514f
C1413 vb a_9312_8456# 0.00353f
C1414 pb14 pb10 0
C1415 nb2 a_18484_20410# 0.00971f
C1416 a_21439_23358# a_22424_20410# 0.12679f
C1417 vinp rn 1.53051f
C1418 a_4044_20410# a_3690_21538# 0.00308f
C1419 a_30400_15860# nb13 0.10513f
C1420 p6 v 0.52489f
C1421 p5 v 0.52489f
C1422 a_8969_23358# a_9954_23358# 0.02326f
C1423 refmid a_10524_8456# 0.00859f
C1424 pa14 pa2 0.00328f
C1425 na0 rp 0
C1426 a_10524_8456# b1 0.15994f
C1427 b1 rn 0.11907f
C1428 vb nb1 0
C1429 refmid rn 0
C1430 vinn rn 0.60548f
C1431 pa5 a_4044_20410# 0
C1432 p4 v 0.52489f
C1433 a_6014_23358# v 2.02759f
C1434 b0 a_10524_8456# 0.37728f
C1435 a_3059_20410# a_2705_21538# 0.00308f
C1436 vb na10 0.00155f
C1437 na6 a_22424_23358# 0.00117f
C1438 b0 rn 0.10602f
C1439 a_12342_8456# g15 0.35081f
C1440 vb a_11130_8456# 1.05703f
C1441 a_19469_20410# na4 0
C1442 a_29319_23358# n12 0.01804f
C1443 na3 nb2 1.77757f
C1444 a_5029_20410# pa6 0
C1445 pa5 pa4 1.03039f
C1446 a_9954_20410# a_9954_23358# 0.41634f
C1447 v pa2 2.60874f
C1448 a_16514_20410# a_17499_20410# 0.02905f
C1449 na0 a_14565_15860# 0
C1450 pa5 pb6 0.17247f
C1451 vb pb9 0
C1452 a_12342_8456# rp 0.05405f
C1453 v a_9600_21538# 0.07832f
C1454 g15 a_7494_8456# 0.00294f
C1455 a_17499_23358# a_16514_23358# 0.02326f
C1456 sp g15 2.46873f
C1457 a_21439_23358# a_20454_23358# 0.02326f
C1458 a_12948_8456# a_9918_8456# 3.73471f
C1459 a_104_23358# a_735_21538# 0.20585f
C1460 a_2330_8340# g15 0.1985f
C1461 a_6282_8456# na14 0
C1462 pa13 a_13990_15860# 0.09041f
C1463 nb7 nb8 1.02201f
C1464 a_8706_8456# a_12342_8456# 0.41776f
C1465 a_10524_8456# a_8100_8456# 0
C1466 pb13 p13 0.03003f
C1467 pb3 p3 0.03003f
C1468 a_8100_8456# rn 0.14328f
C1469 pb3 a_3059_23358# 0.36868f
C1470 pb4 a_4044_23358# 0.36821f
C1471 na5 a_8100_8456# 0
C1472 pb8 pa9 1.81154f
C1473 a_7494_8456# rp 0.00158f
C1474 sp rp 2.48981f
C1475 g15 a_3306_8498# 0.13873f
C1476 pb5 rp 1.93842f
C1477 a_10939_23358# a_9954_23358# 0.02326f
C1478 a_8100_8456# nb0 0
C1479 vb na0 0.00181f
C1480 pb14 a_6282_8456# 0
C1481 a_30400_15860# na14 0.06843f
C1482 nb9 na10 2.39425f
C1483 nb6 n6 0.02934f
C1484 pb13 p12 0
C1485 nb9 a_11130_8456# 0
C1486 a_2330_8340# rp 0.18709f
C1487 na8 nb8 5.42409f
C1488 v a_26364_20410# 1.91294f
C1489 a_27980_21538# a_27349_20410# 0.0013f
C1490 nb3 v 2.14834f
C1491 pa7 rp 1.3631f
C1492 a_8706_8456# a_7494_8456# 0.0117f
C1493 a_29319_20410# a_29950_21538# 0.0013f
C1494 a_8706_8456# sp 0
C1495 p0 a_735_21538# 0.06989f
C1496 v a_26010_21538# 0.07832f
C1497 a_3306_8498# rp 0.29953f
C1498 pa2 pb2 5.4072f
C1499 g4 rs 0.39501f
C1500 n1 a_16514_23358# 0.00455f
C1501 pa12 p12 0.02883f
C1502 pb8 pb6 0.05772f
C1503 a_2330_8340# a_8706_8456# 0.18789f
C1504 nb8 nb14 0
C1505 p11 pa12 0.00118f
C1506 a_27980_21538# n12 0.06334f
C1507 a_11924_20410# v 1.91294f
C1508 n5 nb6 0
C1509 pb8 pb10 0.05772f
C1510 vb a_12342_8456# 0.58395f
C1511 a_8706_8456# a_3306_8498# 0.39464f
C1512 nb1 na14 0
C1513 v a_19115_21538# 0.07986f
C1514 v a_20454_20410# 1.91294f
C1515 n0 a_16514_23358# 0.514f
C1516 a_13554_8456# a_6282_8456# 0.13304f
C1517 pa10 pa12 0.07295f
C1518 pb8 a_7984_20410# 0.01581f
C1519 nb12 a_28334_20410# 0.01581f
C1520 mid a_6888_8456# 0.00145f
C1521 pa0 a_104_23358# 0.00117f
C1522 na10 na14 0.00328f
C1523 a_6282_8456# a_6888_8456# 3.92935f
C1524 a_11130_8456# na14 2.93483f
C1525 nb1 na2 2.3801f
C1526 rs a_11736_8456# 0.00398f
C1527 pa8 a_6999_20410# 0
C1528 vb a_7494_8456# 0.05398f
C1529 a_11130_8456# na2 0.00273f
C1530 p3 a_3059_23358# 0.514f
C1531 vb pb5 0
C1532 pa14 pb11 0
C1533 vb sp 0.60625f
C1534 pb14 a_11130_8456# 0.01439f
C1535 nb2 nb14 0
C1536 a_22424_20410# a_22424_23358# 0.41634f
C1537 a_2330_8340# vb 4.85168f
C1538 vb pa7 0
C1539 pb12 a_13990_15860# 0
C1540 a_9312_8456# a_6888_8456# 0.00778f
C1541 p0 pa0 0.02883f
C1542 nb12 v 2.1562f
C1543 vb a_3306_8498# 0.55748f
C1544 pb14 pb9 0
C1545 nb12 na12 5.42409f
C1546 v pb11 2.05296f
C1547 v rs 2.38305f
C1548 a_19469_23358# a_20100_21538# 0.20585f
C1549 a_3690_21538# a_4044_23358# 0
C1550 a_13554_8456# nb1 0
C1551 a_13554_8456# na10 0
C1552 n11 a_27980_21538# 0.06989f
C1553 a_12948_8456# g15 0.33448f
C1554 a_13554_8456# a_11130_8456# 0.23831f
C1555 nb1 a_17499_20410# 0.01281f
C1556 g4 a_9918_8456# 0.26258f
C1557 a_11130_8456# a_6888_8456# 0.23643f
C1558 nb8 nb6 0.05772f
C1559 na0 na14 0.96058f
C1560 n5 a_21085_21538# 0.06334f
C1561 pa5 a_4044_23358# 0.00428f
C1562 a_27349_20410# nb10 0.00413f
C1563 na0 na2 0.07295f
C1564 pb14 na0 0
C1565 v a_104_23358# 1.85969f
C1566 pb4 pb5 0.9509f
C1567 nb14 nb11 0
C1568 a_12948_8456# rp 0.17367f
C1569 pa13 pb10 0
C1570 pa3 pa2 1.01455f
C1571 a_28334_20410# a_27349_23358# 0.12679f
C1572 p14 a_13894_20410# 0.28604f
C1573 a_18484_20410# a_19115_21538# 0.0013f
C1574 a_2330_8340# pb4 0
C1575 refmid vinp 0
C1576 na3 nb3 5.18114f
C1577 vinn vinp 2.03224f
C1578 vinp b1 0.06199f
C1579 pb4 pa7 0
C1580 a_11736_8456# a_9918_8456# 0.01674f
C1581 a_6645_21538# a_6014_20410# 0.0013f
C1582 a_12342_8456# na14 0
C1583 a_14565_15860# a_13894_23358# 0.00181f
C1584 a_8615_21538# v 0.07832f
C1585 pa11 pb11 5.18114f
C1586 b0 vinp 0.07163f
C1587 a_12948_8456# a_8706_8456# 0.13597f
C1588 n4 a_21085_21538# 0.06989f
C1589 refmid b1 0.39044f
C1590 a_13894_20410# p13 0.22722f
C1591 refmid vinn 0
C1592 vinn b1 0.05966f
C1593 a_4675_21538# p5 0.06334f
C1594 b0 b1 4.06458f
C1595 b0 refmid 0.34267f
C1596 pb14 a_12342_8456# 0
C1597 b0 vinn 0.06934f
C1598 pb8 a_8969_20410# 0.00413f
C1599 a_13554_8456# na0 0
C1600 a_5029_23358# a_5029_20410# 0.41634f
C1601 a_6645_21538# a_6999_23358# 0
C1602 p0 v 0.5077f
C1603 a_18130_21538# a_18484_23358# 0
C1604 na4 a_8100_8456# 0
C1605 na9 v 2.05555f
C1606 p4 a_4675_21538# 0.06989f
C1607 p2 a_2705_21538# 0.06989f
C1608 n5 na5 0.02889f
C1609 nb5 v 2.05128f
C1610 v a_27349_23358# 2.02732f
C1611 v a_9918_8456# 1.31764f
C1612 na12 a_27349_23358# 0.00428f
C1613 a_2330_8340# na14 0.00585f
C1614 pb14 pb5 0
C1615 a_20454_20410# a_21439_20410# 0.02905f
C1616 n14 n13 0.05837f
C1617 a_1089_23358# pa1 0.00495f
C1618 pa10 pb7 0
C1619 pb8 a_7984_23358# 0.36821f
C1620 a_2330_8340# na2 0.00296f
C1621 a_11924_23358# a_12555_21538# 0.20585f
C1622 a_3306_8498# na14 0
C1623 vinp a_8100_8456# 0
C1624 a_19469_23358# a_20454_23358# 0.02326f
C1625 a_12948_8456# vb 0.46706f
C1626 a_12342_8456# a_13554_8456# 3.20718f
C1627 a_2330_8340# pb14 0.00111f
C1628 a_12342_8456# a_6888_8456# 2.78839f
C1629 pb14 pa7 0
C1630 n4 na5 0.00118f
C1631 a_26364_23358# na11 0.00428f
C1632 b1 a_8100_8456# 0.34361f
C1633 v a_2074_20410# 2.24237f
C1634 pb14 a_3306_8498# 0
C1635 v a_9954_23358# 2.02759f
C1636 refmid a_8100_8456# 0.0043f
C1637 vinn a_8100_8456# 0.00141f
C1638 pb8 pb9 0.95149f
C1639 a_1089_23358# pb1 0.36868f
C1640 b0 a_8100_8456# 0.01923f
C1641 a_22070_21538# n6 0.06334f
C1642 a_29950_21538# a_29319_23358# 0.20585f
C1643 a_16514_20410# a_17145_21538# 0.0013f
C1644 sp a_13554_8456# 0
C1645 a_7494_8456# a_6888_8456# 0
C1646 n10 nb10 0.02934f
C1647 v na6 1.64645f
C1648 pb12 pb10 0.05772f
C1649 sp a_6888_8456# 0
C1650 a_11924_20410# pa12 0.37647f
C1651 a_2330_8340# a_13554_8456# 0.2727f
C1652 g4 g15 6.3911f
C1653 a_2330_8340# a_6888_8456# 0.27334f
C1654 a_11924_23358# p13 0.00455f
C1655 nb8 rn 2.07524f
C1656 n13 n12 0.05837f
C1657 p7 pb7 0.03003f
C1658 a_2705_21538# a_2074_23358# 0.20585f
C1659 n9 nb10 0
C1660 a_13554_8456# a_3306_8498# 0.14223f
C1661 na9 a_24394_20410# 0
C1662 pa5 pb5 5.18109f
C1663 pa0 rp 0.99408f
C1664 na7 nb4 0
C1665 n5 a_22070_21538# 0.06989f
C1666 a_25379_23358# a_26364_23358# 0.02326f
C1667 nb3 nb14 0
C1668 a_3306_8498# a_6888_8456# 0.16369f
C1669 a_1089_23358# a_1089_20410# 0.41634f
C1670 a_27349_20410# n12 0
C1671 a_2330_8340# pa5 0
C1672 a_11924_23358# p12 0.514f
C1673 pa11 a_9954_23358# 0.00428f
C1674 p6 pa6 0.02883f
C1675 g4 rp 0.14218f
C1676 n0 nb0 0.02934f
C1677 a_10585_21538# a_9954_23358# 0.20585f
C1678 pa5 pa7 0.09141f
C1679 n4 a_19469_20410# 0
C1680 p5 pa6 0.00118f
C1681 p6 pb7 0
C1682 a_11924_23358# p11 0.01804f
C1683 p1 a_735_21538# 0.06334f
C1684 n3 a_19469_20410# 0.28604f
C1685 pb13 pb11 0.05487f
C1686 na13 a_28334_20410# 0
C1687 a_5660_21538# a_5029_23358# 0.20585f
C1688 g15 a_11736_8456# 0.00339f
C1689 a_22424_20410# a_23409_23358# 0
C1690 a_2074_20410# pb2 0.00971f
C1691 a_6014_23358# pa6 0.00117f
C1692 a_3059_20410# v 1.91545f
C1693 pb0 pa2 0.0886f
C1694 g4 a_8706_8456# 0.42069f
C1695 nb2 rn 2.194f
C1696 a_13990_15860# na1 0.00149f
C1697 a_6014_23358# pb7 0.00181f
C1698 pa13 a_11130_8456# 0
C1699 nb2 na5 0
C1700 n2 a_19469_20410# 0.22722f
C1701 pa8 a_8100_8456# 0.00206f
C1702 a_29319_20410# nb12 0.00413f
C1703 pb11 pa12 2.39425f
C1704 nb2 nb0 0.05772f
C1705 g20 a_10524_8456# 0.02036f
C1706 rp a_11736_8456# 0
C1707 g20 rn 0.44146f
C1708 a_22424_20410# a_23409_20410# 0.02905f
C1709 pa14 rp 1.16941f
C1710 pb14 a_13894_23358# 0.36812f
C1711 na3 nb5 0.01268f
C1712 v a_20100_21538# 0.07832f
C1713 pb8 pb5 0
C1714 na13 v 2.0788f
C1715 g15 v 32.2776f
C1716 a_8706_8456# a_11736_8456# 0.00169f
C1717 vb pa0 0.00451f
C1718 na13 na12 1.04629f
C1719 nb5 a_21439_20410# 0.01281f
C1720 a_24040_21538# a_24394_23358# 0
C1721 pb8 a_2330_8340# 0
C1722 pa13 a_12909_20410# 0.37675f
C1723 pb8 pa7 0.17247f
C1724 a_11570_21538# p12 0.06334f
C1725 n11 a_27349_20410# 0.28604f
C1726 pa14 a_14565_15860# 0.01341f
C1727 g4 vb 2.90237f
C1728 n10 a_25379_20410# 0
C1729 nb12 nb14 0.05711f
C1730 v rp 5.53951f
C1731 nb3 nb6 0
C1732 a_11570_21538# p11 0.06989f
C1733 nb14 rs 0
C1734 nb2 a_19469_20410# 0.00413f
C1735 na10 na11 1.04629f
C1736 a_3059_20410# pb2 0.00413f
C1737 n10 a_27349_20410# 0.22722f
C1738 nb11 rn 1.92342f
C1739 a_8706_8456# v 1.27381f
C1740 a_22424_20410# v 1.91294f
C1741 a_25379_20410# n9 0.28604f
C1742 a_12948_8456# a_13554_8456# 0.17935f
C1743 n11 n12 0.05837f
C1744 v a_14565_15860# 2.79346f
C1745 v a_6645_21538# 0.07832f
C1746 a_12948_8456# a_6888_8456# 0.1005f
C1747 nb12 a_28334_23358# 0.36821f
C1748 a_25025_21538# a_25379_20410# 0.00308f
C1749 na6 a_21439_20410# 0
C1750 pa14 vb 0.07425f
C1751 a_27980_21538# nb11 0.001f
C1752 na9 nb7 0.11205f
C1753 n8 a_25379_20410# 0.22722f
C1754 pb12 a_11130_8456# 0
C1755 p8 a_6999_20410# 0
C1756 nb7 nb5 0.05487f
C1757 nb8 nb10 0.05772f
C1758 n4 na4 0.02883f
C1759 pa11 rp 1.3631f
C1760 a_25379_23358# na10 0.00428f
C1761 pa3 a_2074_20410# 0
C1762 n3 na4 0.00118f
C1763 a_7630_21538# a_7984_20410# 0.00308f
C1764 na8 na9 1.04629f
C1765 rp pb2 2.19334f
C1766 pb12 pb9 0
C1767 na8 nb5 0
C1768 vb v 8.72875f
C1769 a_1089_23358# a_104_20410# 0
C1770 a_30975_15860# v 2.79321f
C1771 p7 a_6999_20410# 0.28604f
C1772 pb1 pa1 5.18473f
C1773 a_6282_8456# sn 0
C1774 mid sn 1.37808f
C1775 vb na12 0.00156f
C1776 v a_20454_23358# 2.02759f
C1777 a_28965_21538# a_28334_20410# 0.0013f
C1778 na9 nb14 0
C1779 pa13 a_2330_8340# 0
C1780 p1 v 0.52516f
C1781 pb12 a_12909_20410# 0.00413f
C1782 a_16514_20410# na1 0
C1783 nb5 nb14 0
C1784 p6 a_6999_20410# 0.22722f
C1785 nb13 v 2.11947f
C1786 g4 na14 0
C1787 nb13 na12 0.08313f
C1788 nb7 na6 0.08313f
C1789 pa14 pb4 0
C1790 a_9312_8456# sn 0
C1791 pb14 pa0 0.78162f
C1792 n11 n10 0.05837f
C1793 a_6014_23358# a_6999_20410# 0.12679f
C1794 pa1 a_1089_20410# 0.37675f
C1795 p14 a_13540_21538# 0.06334f
C1796 pb0 a_104_23358# 0.36821f
C1797 a_20454_20410# a_21085_21538# 0.0013f
C1798 a_27349_23358# a_28334_23358# 0.02326f
C1799 g4 pb14 0
C1800 vb pa11 0
C1801 a_3059_20410# pa3 0.37675f
C1802 a_28965_21538# v 0.07832f
C1803 na8 na6 0.07295f
C1804 nb2 na4 0.0886f
C1805 nb9 v 2.05296f
C1806 vb pb2 0
C1807 a_11924_23358# a_11924_20410# 0.41634f
C1808 pb4 v 2.1205f
C1809 a_13540_21538# p13 0.06989f
C1810 nb3 rn 2.20789f
C1811 nb9 na12 0
C1812 nb3 na5 0.09247f
C1813 p6 a_5029_23358# 0.00455f
C1814 a_30975_15860# a_30304_23358# 0.00181f
C1815 n10 n9 0.05837f
C1816 p5 a_5029_23358# 0.514f
C1817 a_11130_8456# sn 0
C1818 nb14 na6 0.00477f
C1819 pb1 a_1089_20410# 0.01281f
C1820 pa14 na14 0.00394f
C1821 p1 pb2 0
C1822 nb11 nb10 0.95149f
C1823 p4 a_5029_23358# 0.01804f
C1824 pb0 p0 0.02934f
C1825 a_6014_23358# a_5029_23358# 0.02326f
C1826 g4 a_13554_8456# 0.2135f
C1827 pa14 pb14 9.7776f
C1828 n14 a_29950_21538# 0.06334f
C1829 g4 a_6888_8456# 0.19445f
C1830 nb8 a_25379_20410# 0.00413f
C1831 na9 nb6 0
C1832 pa13 a_12909_23358# 0.00495f
C1833 g20 vinp 0.10788f
C1834 nb5 nb6 1.02201f
C1835 a_22424_20410# a_21439_20410# 0.02905f
C1836 p2 v 0.59055f
C1837 a_25025_21538# n9 0.06334f
C1838 v na14 1.63891f
C1839 na5 a_20454_20410# 0
C1840 a_2330_8340# pb12 0
C1841 refmid g20 0.94802f
C1842 pa3 rp 1.76431f
C1843 na13 a_29319_20410# 0.37675f
C1844 a_29950_21538# n13 0.06989f
C1845 g20 vinn 0.21486f
C1846 pb13 rp 1.65764f
C1847 na7 a_11130_8456# 0
C1848 g20 b1 0.20681f
C1849 a_18130_21538# nb1 0.001f
C1850 na14 na12 0.0752f
C1851 n8 n9 0.05837f
C1852 v na2 2.10247f
C1853 b0 g20 0.16994f
C1854 n8 a_25025_21538# 0.06989f
C1855 pb14 v 2.3479f
C1856 pb3 pa2 0.07007f
C1857 nb3 a_19469_20410# 0.01281f
C1858 a_11736_8456# a_6888_8456# 0
C1859 pb4 pb2 0.007f
C1860 rp pa12 1.30791f
C1861 n8 n7 0.05837f
C1862 pb1 pa4 0
C1863 pa14 a_13554_8456# 0
C1864 na3 vb 0
C1865 a_11924_20410# a_11570_21538# 0.00308f
C1866 pa14 a_6888_8456# 0
C1867 pb13 a_14565_15860# 0.05353f
C1868 a_7984_23358# a_7630_21538# 0
C1869 n7 n6 0.05837f
C1870 a_5660_21538# a_5029_20410# 0.0013f
C1871 nb12 rn 2.07524f
C1872 rs a_10524_8456# 0.00369f
C1873 nb2 a_8100_8456# 0
C1874 pa14 pa5 0
C1875 a_20454_23358# a_21439_20410# 0.12679f
C1876 na6 nb6 5.42409f
C1877 rs rn 0.31185f
C1878 na13 nb14 0.17135f
C1879 a_22424_20410# a_23055_21538# 0.0013f
C1880 a_19469_20410# a_20454_20410# 0.02905f
C1881 a_13554_8456# v 0.56189f
C1882 a_19115_21538# a_19469_20410# 0.00308f
C1883 v a_6888_8456# 0.81651f
C1884 a_12342_8456# sn 0
C1885 a_30935_21538# v 0.06864f
C1886 a_13554_8456# na12 0
C1887 g20 a_8100_8456# 0.20261f
C1888 v a_3690_21538# 0.07832f
C1889 p2 pb2 0.02934f
C1890 nb1 na1 5.18473f
C1891 pb14 pa11 0
C1892 pb14 a_14525_21538# 0.001f
C1893 p4 a_3059_23358# 0.00455f
C1894 v a_17499_20410# 1.91491f
C1895 p4 p3 0.05837f
C1896 na14 a_30304_23358# 0.00117f
C1897 vb pa3 0
C1898 vb pb13 0
C1899 v a_2074_23358# 2.30543f
C1900 a_11130_8456# na1 0
C1901 pa10 a_8100_8456# 0
C1902 n5 n6 0.05837f
C1903 pb14 pb2 0
C1904 pa5 v 2.05259f
C1905 na13 a_28334_23358# 0.00428f
C1906 a_7494_8456# sn 0.00121f
C1907 sp sn 4.67211f
C1908 pa1 a_104_20410# 0
C1909 a_11570_21538# pb11 0.001f
C1910 vb pa12 0.00156f
C1911 a_30400_15860# a_30304_20410# 0
C1912 nb11 a_27349_20410# 0.01281f
C1913 pa8 pa10 0.07295f
C1914 vb nb7 0
C1915 a_26364_20410# nb10 0.01581f
C1916 a_18484_20410# na2 0.37647f
C1917 pa9 pb6 0
C1918 pa4 a_4044_20410# 0.37647f
C1919 pb8 pa14 0
C1920 a_23409_23358# a_24394_23358# 0.02326f
C1921 na9 rn 1.3631f
C1922 na8 vb 0.00156f
C1923 pa9 pb10 0.17247f
C1924 a_30935_21538# a_30304_23358# 0.20585f
C1925 a_29319_20410# nb13 0.01281f
C1926 nb5 rn 1.93842f
C1927 p8 pa8 0.02883f
C1928 na0 na1 1.03944f
C1929 nb8 a_25025_21538# 0.001f
C1930 nb5 na5 5.18109f
C1931 pa4 pb6 0.00592f
C1932 a_2074_23358# pb2 0.36821f
C1933 pb4 pa3 0.1569f
C1934 pa9 a_7984_20410# 0
C1935 a_10524_8456# a_9918_8456# 0.00912f
C1936 na3 na14 0
C1937 a_9918_8456# rn 0.2346f
C1938 nb3 na4 2.38971f
C1939 a_23409_20410# a_24394_23358# 0
C1940 n8 nb8 0.02934f
C1941 vb nb14 0.00231f
C1942 pa5 pb2 0
C1943 pb8 v 2.15299f
C1944 pb0 rp 1.87518f
C1945 a_30975_15860# nb14 0.02206f
C1946 nb8 n7 0
C1947 na3 na2 1.01455f
C1948 a_28965_21538# a_29319_20410# 0.00308f
C1949 n5 n4 0.05837f
C1950 pa8 p7 0.00118f
C1951 a_1089_20410# a_104_20410# 0.02905f
C1952 a_27980_21538# a_27349_23358# 0.20585f
C1953 nb9 nb7 0.05487f
C1954 rp pa6 1.30791f
C1955 a_18484_20410# a_17499_20410# 0.02905f
C1956 a_13990_15860# nb1 0
C1957 rp pb7 1.92342f
C1958 nb13 nb14 1.01405f
C1959 pa3 p2 0.00118f
C1960 na4 a_20454_20410# 0.37647f
C1961 na7 a_22424_23358# 0.00428f
C1962 a_22424_20410# nb6 0.01581f
C1963 na8 nb9 0.08313f
C1964 nb12 nb10 0.05772f
C1965 na6 rn 1.30791f
C1966 na5 na6 1.01092f
C1967 pb4 a_4675_21538# 0.001f
C1968 n3 n4 0.05837f
C1969 a_17499_23358# n2 0.00455f
C1970 na3 a_13554_8456# 0
C1971 pb8 pa11 0
C1972 pb14 pa3 0
C1973 n1 a_17499_23358# 0.514f
C1974 pb14 pb13 1.01405f
C1975 n11 nb11 0.03003f
C1976 nb13 a_28334_23358# 0.00181f
C1977 nb4 nb1 0
C1978 nb9 nb14 0
C1979 pa13 pa14 0.98625f
C1980 v a_24394_23358# 2.02759f
C1981 a_2330_8340# na1 0
C1982 a_29319_20410# na14 0
C1983 n10 nb11 0
C1984 nb7 na14 0
C1985 n3 n2 0.05837f
C1986 pb14 pa12 0.0107f
C1987 n0 a_17499_23358# 0.01804f
C1988 nb5 a_22070_21538# 0.001f
C1989 a_26364_20410# a_25379_20410# 0.02905f
C1990 nb4 a_11130_8456# 0
C1991 vb pb0 0
C1992 a_12948_8456# sn 0.00118f
C1993 na13 a_29319_23358# 0.00495f
C1994 a_26364_20410# a_27349_20410# 0.02905f
C1995 a_28965_21538# a_28334_23358# 0.20585f
C1996 vb nb6 0
C1997 a_26010_21538# a_25379_20410# 0.0013f
C1998 na8 na14 0.00328f
C1999 vb pa6 0.00156f
C2000 pa13 v 2.0788f
C2001 pb13 a_13554_8456# 0
C2002 vb pb7 0
C2003 nb3 a_8100_8456# 0
C2004 na0 a_13990_15860# 0
C2005 p6 a_5029_20410# 0
C2006 n1 n2 0.05837f
C2007 p5 a_5029_20410# 0.28604f
C2008 pa3 a_2074_23358# 0.00428f
C2009 nb14 na14 9.7776f
C2010 pa9 a_8969_20410# 0.37675f
C2011 rs vinp 0.07787f
C2012 pa5 pa3 0.03135f
C2013 p4 a_5029_20410# 0.22722f
C2014 a_6014_23358# a_5029_20410# 0
C2015 nb14 na2 0.00501f
C2016 n0 n1 0.05837f
C2017 g15 a_10524_8456# 0.00227f
C2018 na9 nb10 0.17247f
C2019 nb7 a_13554_8456# 0
C2020 refmid rs 2.03919f
C2021 g15 rn 0.80603f
C2022 rs b1 0.44699f
C2023 na13 rn 1.23043f
C2024 pb14 nb14 0
C2025 vinn rs 0.07617f
C2026 a_12555_21538# p13 0.06334f
C2027 a_4044_20410# a_4044_23358# 0.41634f
C2028 b0 rs 0.3068f
C2029 a_7984_23358# pa9 0.00428f
C2030 na8 a_13554_8456# 0
C2031 pa13 pa11 0.09141f
C2032 a_1089_23358# a_735_21538# 0
C2033 nb2 n2 0.02934f
C2034 a_24394_20410# a_24394_23358# 0.41634f
C2035 rp a_10524_8456# 0
C2036 rp rn 4.1989f
C2037 pa4 a_4044_23358# 0.00117f
C2038 a_12555_21538# p12 0.06989f
C2039 nb2 n1 0
C2040 pb4 pa6 0.11083f
C2041 v na11 2.05555f
C2042 a_7630_21538# a_6999_23358# 0.20585f
C2043 rp nb0 0
C2044 pa14 pb12 0.10801f
C2045 na12 na11 1.01092f
C2046 pa9 pb9 5.18114f
C2047 a_2330_8340# pa1 0.00123f
C2048 a_8969_20410# a_7984_20410# 0.02905f
C2049 a_30935_21538# nb14 0.001f
C2050 a_13554_8456# nb14 0
C2051 a_8706_8456# a_10524_8456# 0.00169f
C2052 nb14 a_6888_8456# 0
C2053 nb5 na4 0.08264f
C2054 p14 p13 0.05837f
C2055 a_8706_8456# rn 0.34297f
C2056 a_14565_15860# rn 0
C2057 a_20454_23358# a_21085_21538# 0.20585f
C2058 n11 a_26364_20410# 0
C2059 a_14565_15860# nb0 0
C2060 a_16514_23358# a_17499_20410# 0.12679f
C2061 a_19469_20410# a_20100_21538# 0.0013f
C2062 a_8100_8456# pb11 0
C2063 rs a_8100_8456# 0.18485f
C2064 a_11130_8456# pb10 0
C2065 nb12 n12 0.02934f
C2066 a_7984_23358# a_7984_20410# 0.41634f
C2067 pb12 v 2.1562f
C2068 n10 a_26364_20410# 0.28604f
C2069 na14 nb6 0
C2070 a_2330_8340# pb1 0
C2071 na10 a_26364_23358# 0.00117f
C2072 v a_17145_21538# 0.07832f
C2073 pb14 pb0 0.96495f
C2074 nb13 a_29319_23358# 0.36868f
C2075 pb3 a_3059_20410# 0.01281f
C2076 a_2074_20410# a_3059_23358# 0
C2077 p3 a_2074_20410# 0
C2078 a_25379_23358# v 2.02732f
C2079 p13 p12 0.05837f
C2080 n10 a_26010_21538# 0.06334f
C2081 vinp a_9918_8456# 0.06549f
C2082 pb10 pb9 1.02201f
C2083 mid a_6282_8456# 0.00221f
C2084 g4 sn 2.17744f
C2085 a_5660_21538# p6 0.06334f
C2086 a_26364_20410# n9 0.22722f
C2087 a_5660_21538# p5 0.06989f
C2088 a_9918_8456# b1 0.56176f
C2089 a_6645_21538# a_6999_20410# 0.00308f
C2090 pb14 pa6 0.00477f
C2091 refmid a_9918_8456# 0.00879f
C2092 na4 na6 0.07295f
C2093 a_28965_21538# a_29319_23358# 0
C2094 vinn a_9918_8456# 0.06013f
C2095 pb14 a_13894_20410# 0.01581f
C2096 vb rn 0.12997f
C2097 pb14 pb7 0
C2098 vb na5 0
C2099 b0 a_9918_8456# 0.10118f
C2100 a_26010_21538# n9 0.06989f
C2101 a_5660_21538# a_6014_23358# 0
C2102 p11 p12 0.05837f
C2103 vb nb0 0
C2104 a_19469_23358# a_18484_23358# 0.02326f
C2105 a_20454_23358# na5 0.00428f
C2106 na0 a_16514_20410# 0.37647f
C2107 na9 a_25379_20410# 0.37675f
C2108 pb12 pa11 0.17247f
C2109 na7 a_23409_23358# 0.00495f
C2110 p10 p11 0.05837f
C2111 mid a_9312_8456# 0.02674f
C2112 a_6282_8456# a_9312_8456# 0.00784f
C2113 sn a_11736_8456# 0
C2114 nb13 rn 1.65764f
C2115 a_27349_20410# a_27349_23358# 0.41634f
C2116 p10 pa10 0.02883f
C2117 pb3 rp 2.20789f
C2118 n11 nb12 0
C2119 a_22070_21538# a_22424_20410# 0.00308f
C2120 na7 a_23409_20410# 0.37675f
C2121 p10 p9 0.05837f
C2122 p9 pa10 0.00118f
C2123 a_3059_20410# a_3059_23358# 0.41634f
C2124 nb5 a_8100_8456# 0
C2125 na13 nb10 0
C2126 a_3059_20410# p3 0.28604f
C2127 a_2330_8340# pa9 0
C2128 a_9918_8456# a_8100_8456# 0.26294f
C2129 pa9 pa7 0.09141f
C2130 a_6282_8456# a_11130_8456# 0.13998f
C2131 mid a_11130_8456# 0.00119f
C2132 a_27349_23358# n12 0.00455f
C2133 pa13 pb13 5.20657f
C2134 pa5 pa6 1.01092f
C2135 a_29319_23358# na14 0.00428f
C2136 nb9 rn 1.92342f
C2137 pa4 pb5 0.08264f
C2138 v sn 13.9122f
C2139 pa5 pb7 0.01292f
C2140 a_25379_23358# a_24394_20410# 0
C2141 a_20454_23358# a_19469_20410# 0
C2142 pb5 pb6 1.02201f
C2143 pa13 pa12 1.04629f
C2144 na8 a_24394_23358# 0.00117f
C2145 a_2330_8340# pa4 0.00201f
C2146 p8 p9 0.05837f
C2147 a_1089_23358# v 2.02804f
C2148 a_2330_8340# pb6 0
C2149 pa7 pb6 1.81154f
C2150 n5 a_20454_20410# 0
C2151 a_7984_23358# a_8969_20410# 0.12679f
C2152 pb10 a_10939_20410# 0.00413f
C2153 a_2330_8340# pb10 0
C2154 nb3 n3 0.03003f
C2155 pa9 a_8969_23358# 0.00495f
C2156 a_8100_8456# na6 0.00143f
C2157 pb3 vb 0
C2158 na7 v 2.05555f
C2159 na14 rn 1.15856f
C2160 na14 na5 0
C2161 a_11130_8456# nb1 0
C2162 na14 nb0 0.16989f
C2163 g15 vinp 0.06609f
C2164 a_8969_20410# pb9 0.01281f
C2165 na2 rn 1.40178f
C2166 na10 a_11130_8456# 0.00494f
C2167 a_18130_21538# v 0.07832f
C2168 nb3 n2 0
C2169 pb8 pa6 0.00592f
C2170 pb14 rn 0
C2171 refmid g15 0.72459f
C2172 na2 nb0 0.11083f
C2173 p8 p7 0.05837f
C2174 pb8 pb7 1.02201f
C2175 n11 a_27349_23358# 0.514f
C2176 n4 a_20454_20410# 0.28604f
C2177 g15 vinn 0.06603f
C2178 g15 b1 0.17892f
C2179 n3 a_19115_21538# 0.06334f
C2180 n3 a_20454_20410# 0.22722f
C2181 pb14 nb0 0.00204f
C2182 rp vinp 0.54423f
C2183 b0 g15 0.08962f
C2184 a_2074_20410# a_1720_21538# 0.00308f
C2185 a_7630_21538# v 0.07832f
C2186 a_7984_23358# pb9 0.00181f
C2187 vb nb10 0
C2188 a_12555_21538# a_11924_20410# 0.0013f
C2189 n10 a_27349_23358# 0.01804f
C2190 vinp g 1.48386f
C2191 vinn g 2.10363f
C2192 b1 g 2.69342f
C2193 b0 g 3.77251f
C2194 n14 g 1.18691f
C2195 n13 g 0.69845f
C2196 n12 g 0.69959f
C2197 n11 g 0.69845f
C2198 n10 g 0.69959f
C2199 n9 g 0.69845f
C2200 n8 g 0.69959f
C2201 n7 g 0.69845f
C2202 n6 g 0.69959f
C2203 n5 g 0.69845f
C2204 n4 g 0.69959f
C2205 n3 g 0.69845f
C2206 n2 g 0.69959f
C2207 n1 g 0.6992f
C2208 n0 g 0.82283f
C2209 p14 g 1.15747f
C2210 p13 g 0.69845f
C2211 p12 g 0.69959f
C2212 p11 g 0.69845f
C2213 p10 g 0.69959f
C2214 p9 g 0.69845f
C2215 p8 g 0.69959f
C2216 p7 g 0.69845f
C2217 p6 g 0.69959f
C2218 p5 g 0.69845f
C2219 p4 g 0.69959f
C2220 p3 g 0.69845f
C2221 p2 g 0.69959f
C2222 p1 g 0.69845f
C2223 p0 g 0.85906f
C2224 v g 0.9832p
C2225 mid g 6.1992f ; **FLOATING
C2226 refmid g 5.12065f ; **FLOATING
C2227 rs g 3.31777f ; **FLOATING
C2228 g20 g 4.51081f ; **FLOATING
C2229 g15 g 4.31626f ; **FLOATING
C2230 g4 g 3.31027f ; **FLOATING
C2231 a_11736_8456# g 0.11469f ; **FLOATING
C2232 a_10524_8456# g 0.06739f ; **FLOATING
C2233 a_9312_8456# g 0.21585f ; **FLOATING
C2234 a_7494_8456# g 0.08256f ; **FLOATING
C2235 a_3306_8498# g 3.39265f ; **FLOATING
C2236 a_13554_8456# g 2.95935f ; **FLOATING
C2237 a_12948_8456# g 2.10663f ; **FLOATING
C2238 a_8706_8456# g 1.6474f ; **FLOATING
C2239 a_12342_8456# g 3.86508f ; **FLOATING
C2240 a_9918_8456# g 2.44996f ; **FLOATING
C2241 a_11130_8456# g 5.12525f ; **FLOATING
C2242 a_6888_8456# g 3.25802f ; **FLOATING
C2243 a_8100_8456# g 5.38006f ; **FLOATING
C2244 a_6282_8456# g 3.37565f ; **FLOATING
C2245 vb g 12.0153f ; **FLOATING
C2246 a_2330_8340# g 5.61732f ; **FLOATING
C2247 a_30975_15860# g 4.98935f ; **FLOATING
C2248 a_30400_15860# g 4.83988f ; **FLOATING
C2249 rn g 54.0432f ; **FLOATING
C2250 a_14565_15860# g 4.89858f ; **FLOATING
C2251 a_13990_15860# g 4.78542f ; **FLOATING
C2252 rp g 55.2404f ; **FLOATING
C2253 nb14 g 9.82096f ; **FLOATING
C2254 na14 g 9.26476f ; **FLOATING
C2255 nb13 g 5.04165f ; **FLOATING
C2256 na13 g 6.46655f ; **FLOATING
C2257 nb12 g 5.22742f ; **FLOATING
C2258 na12 g 6.19477f ; **FLOATING
C2259 nb11 g 4.9876f ; **FLOATING
C2260 na11 g 6.46078f ; **FLOATING
C2261 nb10 g 5.22588f ; **FLOATING
C2262 na10 g 6.18611f ; **FLOATING
C2263 nb9 g 4.9876f ; **FLOATING
C2264 na9 g 6.46075f ; **FLOATING
C2265 nb8 g 5.22542f ; **FLOATING
C2266 na8 g 6.18535f ; **FLOATING
C2267 nb7 g 4.9876f ; **FLOATING
C2268 na7 g 6.46078f ; **FLOATING
C2269 nb6 g 5.22586f ; **FLOATING
C2270 na6 g 6.18222f ; **FLOATING
C2271 nb5 g 4.97062f ; **FLOATING
C2272 na5 g 6.38651f ; **FLOATING
C2273 nb4 g 5.14738f ; **FLOATING
C2274 na4 g 6.0683f ; **FLOATING
C2275 nb3 g 4.92326f ; **FLOATING
C2276 na3 g 6.34541f ; **FLOATING
C2277 nb2 g 5.12937f ; **FLOATING
C2278 na2 g 6.11906f ; **FLOATING
C2279 nb1 g 5.04498f ; **FLOATING
C2280 na1 g 6.79329f ; **FLOATING
C2281 nb0 g 5.99808f ; **FLOATING
C2282 na0 g 8.53096f ; **FLOATING
C2283 pb14 g 10.0361f ; **FLOATING
C2284 pa14 g 9.36889f ; **FLOATING
C2285 pb13 g 5.03762f ; **FLOATING
C2286 pa13 g 6.46696f ; **FLOATING
C2287 pb12 g 5.22887f ; **FLOATING
C2288 pa12 g 6.18291f ; **FLOATING
C2289 pb11 g 4.98759f ; **FLOATING
C2290 pa11 g 6.46076f ; **FLOATING
C2291 pb10 g 5.22586f ; **FLOATING
C2292 pa10 g 6.18277f ; **FLOATING
C2293 pb9 g 4.98759f ; **FLOATING
C2294 pa9 g 6.46076f ; **FLOATING
C2295 pb8 g 5.22586f ; **FLOATING
C2296 pa8 g 6.1746f ; **FLOATING
C2297 pb7 g 4.98759f ; **FLOATING
C2298 pa7 g 6.46076f ; **FLOATING
C2299 pb6 g 5.22588f ; **FLOATING
C2300 pa6 g 6.18818f ; **FLOATING
C2301 pb5 g 4.97063f ; **FLOATING
C2302 pa5 g 6.38653f ; **FLOATING
C2303 pb4 g 5.14741f ; **FLOATING
C2304 pa4 g 6.06613f ; **FLOATING
C2305 pb3 g 4.92348f ; **FLOATING
C2306 pa3 g 6.34394f ; **FLOATING
C2307 pb2 g 5.07643f ; **FLOATING
C2308 pa2 g 6.01476f ; **FLOATING
C2309 pb1 g 5.04302f ; **FLOATING
C2310 pa1 g 6.89508f ; **FLOATING
C2311 pb0 g 5.90122f ; **FLOATING
C2312 pa0 g 8.46486f ; **FLOATING
C2313 a_30935_21538# g 0.21817f ; **FLOATING
C2314 a_29950_21538# g 0.10816f ; **FLOATING
C2315 a_28965_21538# g 0.10816f ; **FLOATING
C2316 a_27980_21538# g 0.10816f ; **FLOATING
C2317 a_26995_21538# g 0.10816f ; **FLOATING
C2318 a_26010_21538# g 0.10816f ; **FLOATING
C2319 a_25025_21538# g 0.10816f ; **FLOATING
C2320 a_24040_21538# g 0.10816f ; **FLOATING
C2321 a_23055_21538# g 0.10816f ; **FLOATING
C2322 a_22070_21538# g 0.10816f ; **FLOATING
C2323 a_21085_21538# g 0.10816f ; **FLOATING
C2324 a_20100_21538# g 0.10816f ; **FLOATING
C2325 a_19115_21538# g 0.10816f ; **FLOATING
C2326 a_18130_21538# g 0.10816f ; **FLOATING
C2327 a_17145_21538# g 0.10903f ; **FLOATING
C2328 a_14525_21538# g 0.20012f ; **FLOATING
C2329 a_13540_21538# g 0.10816f ; **FLOATING
C2330 a_12555_21538# g 0.10816f ; **FLOATING
C2331 a_11570_21538# g 0.10816f ; **FLOATING
C2332 a_10585_21538# g 0.10816f ; **FLOATING
C2333 a_9600_21538# g 0.10816f ; **FLOATING
C2334 a_8615_21538# g 0.10816f ; **FLOATING
C2335 a_7630_21538# g 0.10816f ; **FLOATING
C2336 a_6645_21538# g 0.10816f ; **FLOATING
C2337 a_5660_21538# g 0.10816f ; **FLOATING
C2338 a_4675_21538# g 0.10816f ; **FLOATING
C2339 a_3690_21538# g 0.10816f ; **FLOATING
C2340 a_2705_21538# g 0.10816f ; **FLOATING
C2341 a_1720_21538# g 0.10816f ; **FLOATING
C2342 a_735_21538# g 0.10816f ; **FLOATING
C2343 a_30304_23358# g 0.96618f ; **FLOATING
C2344 a_29319_23358# g 0.69345f ; **FLOATING
C2345 a_28334_23358# g 0.69622f ; **FLOATING
C2346 a_27349_23358# g 0.69345f ; **FLOATING
C2347 a_26364_23358# g 0.69622f ; **FLOATING
C2348 a_25379_23358# g 0.69345f ; **FLOATING
C2349 a_24394_23358# g 0.69622f ; **FLOATING
C2350 a_23409_23358# g 0.69345f ; **FLOATING
C2351 a_22424_23358# g 0.69622f ; **FLOATING
C2352 a_21439_23358# g 0.69345f ; **FLOATING
C2353 a_20454_23358# g 0.69622f ; **FLOATING
C2354 a_19469_23358# g 0.69345f ; **FLOATING
C2355 a_18484_23358# g 0.65792f ; **FLOATING
C2356 a_17499_23358# g 0.69408f ; **FLOATING
C2357 a_16514_23358# g 0.81991f ; **FLOATING
C2358 a_30304_20410# g 1.45792f ; **FLOATING
C2359 a_29319_20410# g 1.35443f ; **FLOATING
C2360 a_28334_20410# g 1.35649f ; **FLOATING
C2361 a_27349_20410# g 1.35443f ; **FLOATING
C2362 a_26364_20410# g 1.35649f ; **FLOATING
C2363 a_25379_20410# g 1.35443f ; **FLOATING
C2364 a_24394_20410# g 1.35649f ; **FLOATING
C2365 a_23409_20410# g 1.35443f ; **FLOATING
C2366 a_22424_20410# g 1.35649f ; **FLOATING
C2367 a_21439_20410# g 1.35443f ; **FLOATING
C2368 a_20454_20410# g 1.35649f ; **FLOATING
C2369 a_19469_20410# g 1.35443f ; **FLOATING
C2370 a_18484_20410# g 1.27605f ; **FLOATING
C2371 a_17499_20410# g 1.35758f ; **FLOATING
C2372 a_13894_23358# g 0.94842f ; **FLOATING
C2373 a_12909_23358# g 0.69345f ; **FLOATING
C2374 a_11924_23358# g 0.69622f ; **FLOATING
C2375 a_10939_23358# g 0.69345f ; **FLOATING
C2376 a_9954_23358# g 0.69622f ; **FLOATING
C2377 a_8969_23358# g 0.69345f ; **FLOATING
C2378 a_7984_23358# g 0.69622f ; **FLOATING
C2379 a_6999_23358# g 0.69345f ; **FLOATING
C2380 a_6014_23358# g 0.69622f ; **FLOATING
C2381 a_5029_23358# g 0.69345f ; **FLOATING
C2382 a_4044_23358# g 0.69622f ; **FLOATING
C2383 a_3059_23358# g 0.69345f ; **FLOATING
C2384 a_2074_23358# g 0.65792f ; **FLOATING
C2385 a_1089_23358# g 0.69345f ; **FLOATING
C2386 a_104_23358# g 0.84054f ; **FLOATING
C2387 a_16514_20410# g 1.99704f ; **FLOATING
C2388 a_13894_20410# g 1.45592f ; **FLOATING
C2389 a_12909_20410# g 1.35443f ; **FLOATING
C2390 a_11924_20410# g 1.35649f ; **FLOATING
C2391 a_10939_20410# g 1.35443f ; **FLOATING
C2392 a_9954_20410# g 1.35649f ; **FLOATING
C2393 a_8969_20410# g 1.35443f ; **FLOATING
C2394 a_7984_20410# g 1.35649f ; **FLOATING
C2395 a_6999_20410# g 1.35443f ; **FLOATING
C2396 a_6014_20410# g 1.35649f ; **FLOATING
C2397 a_5029_20410# g 1.35443f ; **FLOATING
C2398 a_4044_20410# g 1.35649f ; **FLOATING
C2399 a_3059_20410# g 1.35443f ; **FLOATING
C2400 a_2074_20410# g 1.27605f ; **FLOATING
C2401 a_1089_20410# g 1.35443f ; **FLOATING
C2402 a_104_20410# g 2.06677f ; **FLOATING
C2403 sn g 22.351f ; **FLOATING
C2404 sp g 22.4917f ; **FLOATING
.ends
