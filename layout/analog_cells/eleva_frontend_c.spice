* NGSPICE file created from front_flat.ext - technology: sky130A

.subckt front_flat vinp vinn b0 b1 rp rn v g
X0 mid sn g sky130_fd_pr__res_high_po_0p69 l=80
X1 v a_8706_8456# g4 v sky130_fd_pr__pfet_01v8 ad=0.6972 pd=3.34 as=0.6972 ps=3.34 w=0.84 l=0.15
X2 v g15 sn v sky130_fd_pr__pfet_01v8 ad=0.5 pd=2 as=0.5 ps=2 w=1 l=2
X3 v g20 sp v sky130_fd_pr__pfet_01v8 ad=0.5 pd=2 as=0.5 ps=2 w=1 l=2
X4 sn g20 v v sky130_fd_pr__pfet_01v8 ad=0.5 pd=2 as=0.5 ps=2 w=1 l=2
X5 sn vb v v sky130_fd_pr__pfet_01v8 ad=0.5 pd=2 as=0.73 ps=3.46 w=1 l=2
X6 sp g4 v v sky130_fd_pr__pfet_01v8 ad=0.5 pd=2 as=0.5 ps=2 w=1 l=2
X7 v g15 sn v sky130_fd_pr__pfet_01v8 ad=0.5 pd=2 as=0.5 ps=2 w=1 l=2
X8 vb a_12948_8456# g15 g sky130_fd_pr__nfet_01v8 ad=0.3486 pd=2.5 as=0.3486 ps=2.5 w=0.42 l=0.15
X9 v g20 sp v sky130_fd_pr__pfet_01v8 ad=0.5 pd=2 as=0.5 ps=2 w=1 l=2
X10 vb a_9918_8456# g20 g sky130_fd_pr__nfet_01v8 ad=0.3486 pd=2.5 as=0.3486 ps=2.5 w=0.42 l=0.15
X11 sn g15 v v sky130_fd_pr__pfet_01v8 ad=0.5 pd=2 as=0.73 ps=3.46 w=1 l=2
X12 sp g15 v v sky130_fd_pr__pfet_01v8 ad=0.5 pd=2 as=0.5 ps=2 w=1 l=2
X13 rn vinp sn sn sky130_fd_pr__pfet_01v8_lvt ad=5.7 pd=13.9 as=6 ps=8 w=6 l=1
X14 g a_2330_8340# a_2330_8340# g sky130_fd_pr__nfet_01v8 ad=1.66 pd=5.66 as=1.66 ps=5.66 w=2 l=2
X15 v g20 sn v sky130_fd_pr__pfet_01v8 ad=0.5 pd=2 as=0.5 ps=2 w=1 l=2
X16 g a_6888_8456# a_9918_8456# g sky130_fd_pr__nfet_01v8 ad=0.3486 pd=2.5 as=0.3486 ps=2.5 w=0.42 l=0.15
X17 sn g20 v v sky130_fd_pr__pfet_01v8 ad=0.5 pd=2 as=0.73 ps=3.46 w=1 l=2
X18 v a_12342_8456# a_12948_8456# v sky130_fd_pr__pfet_01v8 ad=0.6972 pd=3.34 as=0.6972 ps=3.34 w=0.84 l=0.15
X19 sp g20 v v sky130_fd_pr__pfet_01v8 ad=0.5 pd=2 as=0.5 ps=2 w=1 l=2
X20 v g20 sn v sky130_fd_pr__pfet_01v8 ad=0.5 pd=2 as=0.5 ps=2 w=1 l=2
X21 v a_6282_8456# a_9312_8456# v sky130_fd_pr__pfet_01v8 ad=0.6972 pd=3.34 as=0.6972 ps=3.34 w=0.84 l=0.15
X22 g b1 a_8100_8456# g sky130_fd_pr__nfet_01v8 ad=0.3486 pd=2.5 as=0.3486 ps=2.5 w=0.42 l=0.15
X23 v g4 sn v sky130_fd_pr__pfet_01v8 ad=0.5 pd=2 as=0.5 ps=2 w=1 l=2
X24 sp vinn rp sp sky130_fd_pr__pfet_01v8_lvt ad=6 pd=8 as=5.7 ps=13.9 w=6 l=1
X25 a_10524_8456# b1 a_11130_8456# v sky130_fd_pr__pfet_01v8 ad=0.6972 pd=3.34 as=0.6972 ps=3.34 w=0.84 l=0.15
X26 rs a_2330_8340# vb g sky130_fd_pr__nfet_01v8 ad=6.64 pd=17.66 as=6.64 ps=17.66 w=8 l=2
X27 sn g20 v v sky130_fd_pr__pfet_01v8 ad=0.5 pd=2 as=0.73 ps=3.46 w=1 l=2
X28 sp g20 v v sky130_fd_pr__pfet_01v8 ad=0.5 pd=2 as=0.5 ps=2 w=1 l=2
X29 v a_6282_8456# a_7494_8456# v sky130_fd_pr__pfet_01v8 ad=0.6972 pd=3.34 as=0.6972 ps=3.34 w=0.84 l=0.15
X30 v a_11130_8456# a_11736_8456# v sky130_fd_pr__pfet_01v8 ad=0.6972 pd=3.34 as=0.6972 ps=3.34 w=0.84 l=0.15
X31 v g15 sn v sky130_fd_pr__pfet_01v8 ad=0.5 pd=2 as=0.5 ps=2 w=1 l=2
X32 vb a_13554_8456# g20 v sky130_fd_pr__pfet_01v8 ad=0.6972 pd=3.34 as=0.6972 ps=3.34 w=0.84 l=0.15
X33 sp g15 v v sky130_fd_pr__pfet_01v8 ad=0.5 pd=2 as=0.5 ps=2 w=1 l=2
X34 v g20 sn v sky130_fd_pr__pfet_01v8 ad=0.5 pd=2 as=0.5 ps=2 w=1 l=2
X35 v vb a_2330_8340# v sky130_fd_pr__pfet_01v8 ad=1.66 pd=5.66 as=1.66 ps=5.66 w=2 l=2
X36 sp g15 v v sky130_fd_pr__pfet_01v8 ad=0.5 pd=2 as=0.5 ps=2 w=1 l=2
X37 sn g4 v v sky130_fd_pr__pfet_01v8 ad=0.5 pd=2 as=0.5 ps=2 w=1 l=2
X38 g a_9918_8456# a_13554_8456# g sky130_fd_pr__nfet_01v8 ad=0.3486 pd=2.5 as=0.3486 ps=2.5 w=0.42 l=0.15
X39 v g20 sn v sky130_fd_pr__pfet_01v8 ad=0.5 pd=2 as=0.5 ps=2 w=1 l=2
X40 rn g sky130_fd_pr__cap_mim_m3_1 l=21.8 w=21.8
X41 v b0 a_6282_8456# v sky130_fd_pr__pfet_01v8 ad=0.6972 pd=3.34 as=0.6972 ps=3.34 w=0.84 l=0.15
X42 sp g20 v v sky130_fd_pr__pfet_01v8 ad=0.5 pd=2 as=0.5 ps=2 w=1 l=2
X43 sn g15 v v sky130_fd_pr__pfet_01v8 ad=0.5 pd=2 as=0.5 ps=2 w=1 l=2
X44 g a_11130_8456# a_12342_8456# g sky130_fd_pr__nfet_01v8 ad=0.3486 pd=2.5 as=0.3486 ps=2.5 w=0.42 l=0.15
X45 g a_9918_8456# a_12342_8456# g sky130_fd_pr__nfet_01v8 ad=0.3486 pd=2.5 as=0.3486 ps=2.5 w=0.42 l=0.15
X46 sp vinn rp sp sky130_fd_pr__pfet_01v8_lvt ad=6 pd=8 as=5.7 ps=13.9 w=6 l=1
X47 v g15 sp v sky130_fd_pr__pfet_01v8 ad=0.5 pd=2 as=0.5 ps=2 w=1 l=2
X48 rp vinn sp sp sky130_fd_pr__pfet_01v8_lvt ad=5.7 pd=13.9 as=6 ps=8 w=6 l=1
X49 vb a_12342_8456# g15 v sky130_fd_pr__pfet_01v8 ad=0.6972 pd=3.34 as=0.6972 ps=3.34 w=0.84 l=0.15
X50 sn g20 v v sky130_fd_pr__pfet_01v8 ad=0.5 pd=2 as=0.5 ps=2 w=1 l=2
X51 sp g20 v v sky130_fd_pr__pfet_01v8 ad=0.5 pd=2 as=0.5 ps=2 w=1 l=2
X52 rs refmid g sky130_fd_pr__res_high_po_0p69 l=97.1
X53 rp g sky130_fd_pr__cap_mim_m3_1 l=21.8 w=21.8
X54 v g15 sp v sky130_fd_pr__pfet_01v8 ad=0.5 pd=2 as=0.5 ps=2 w=1 l=2
X55 v a_9918_8456# a_13554_8456# v sky130_fd_pr__pfet_01v8 ad=0.6972 pd=3.34 as=0.6972 ps=3.34 w=0.84 l=0.15
X56 sn g20 v v sky130_fd_pr__pfet_01v8 ad=0.5 pd=2 as=0.5 ps=2 w=1 l=2
X57 v g15 sn v sky130_fd_pr__pfet_01v8 ad=0.73 pd=3.46 as=0.5 ps=2 w=1 l=2
X58 v g20 sp v sky130_fd_pr__pfet_01v8 ad=0.5 pd=2 as=0.5 ps=2 w=1 l=2
X59 sp mid g sky130_fd_pr__res_high_po_0p69 l=80
X60 g b0 a_11130_8456# g sky130_fd_pr__nfet_01v8 ad=0.3486 pd=2.5 as=0.3486 ps=2.5 w=0.42 l=0.15
X61 sn g15 v v sky130_fd_pr__pfet_01v8 ad=0.5 pd=2 as=0.5 ps=2 w=1 l=2
X62 refmid g g sky130_fd_pr__res_high_po_0p69 l=97.1
X63 v g15 sn v sky130_fd_pr__pfet_01v8 ad=0.73 pd=3.46 as=0.5 ps=2 w=1 l=2
X64 v g20 sp v sky130_fd_pr__pfet_01v8 ad=0.5 pd=2 as=0.5 ps=2 w=1 l=2
X65 g a_8100_8456# a_8706_8456# g sky130_fd_pr__nfet_01v8 ad=0.3486 pd=2.5 as=0.3486 ps=2.5 w=0.42 l=0.15
X66 g a_6282_8456# a_9918_8456# g sky130_fd_pr__nfet_01v8 ad=0.3486 pd=2.5 as=0.3486 ps=2.5 w=0.42 l=0.15
X67 v g4 sp v sky130_fd_pr__pfet_01v8 ad=0.5 pd=2 as=0.5 ps=2 w=1 l=2
X68 sn g15 v v sky130_fd_pr__pfet_01v8 ad=0.5 pd=2 as=0.5 ps=2 w=1 l=2
X69 v g20 sn v sky130_fd_pr__pfet_01v8 ad=0.73 pd=3.46 as=0.5 ps=2 w=1 l=2
X70 a_7494_8456# b1 a_8100_8456# v sky130_fd_pr__pfet_01v8 ad=0.6972 pd=3.34 as=0.6972 ps=3.34 w=0.84 l=0.15
X71 a_11736_8456# a_9918_8456# a_12342_8456# v sky130_fd_pr__pfet_01v8 ad=0.6972 pd=3.34 as=0.6972 ps=3.34 w=0.84 l=0.15
X72 g b1 a_6888_8456# g sky130_fd_pr__nfet_01v8 ad=0.3486 pd=2.5 as=0.3486 ps=2.5 w=0.42 l=0.15
X73 v g15 sp v sky130_fd_pr__pfet_01v8 ad=0.73 pd=3.46 as=0.5 ps=2 w=1 l=2
X74 rp vinn sp sp sky130_fd_pr__pfet_01v8_lvt ad=5.7 pd=13.9 as=6 ps=8 w=6 l=1
X75 g a_3306_8498# vb g sky130_fd_pr__nfet_01v8 ad=0.415 pd=2.66 as=0.415 ps=2.66 w=0.5 l=1
X76 v g15 sp v sky130_fd_pr__pfet_01v8 ad=0.5 pd=2 as=0.5 ps=2 w=1 l=2
X77 sn g20 v v sky130_fd_pr__pfet_01v8 ad=0.5 pd=2 as=0.5 ps=2 w=1 l=2
X78 a_9312_8456# a_6888_8456# a_9918_8456# v sky130_fd_pr__pfet_01v8 ad=0.6972 pd=3.34 as=0.6972 ps=3.34 w=0.84 l=0.15
X79 vb a_8706_8456# g4 g sky130_fd_pr__nfet_01v8 ad=0.3486 pd=2.5 as=0.3486 ps=2.5 w=0.42 l=0.15
X80 v g20 sn v sky130_fd_pr__pfet_01v8 ad=0.73 pd=3.46 as=0.5 ps=2 w=1 l=2
X81 v a_9918_8456# g20 v sky130_fd_pr__pfet_01v8 ad=0.6972 pd=3.34 as=0.6972 ps=3.34 w=0.84 l=0.15
X82 v g15 sp v sky130_fd_pr__pfet_01v8 ad=0.73 pd=3.46 as=0.5 ps=2 w=1 l=2
X83 v g15 sn v sky130_fd_pr__pfet_01v8 ad=0.5 pd=2 as=0.5 ps=2 w=1 l=2
X84 v g20 sp v sky130_fd_pr__pfet_01v8 ad=0.5 pd=2 as=0.5 ps=2 w=1 l=2
X85 sn g20 v v sky130_fd_pr__pfet_01v8 ad=0.5 pd=2 as=0.5 ps=2 w=1 l=2
X86 sn vinp rn sn sky130_fd_pr__pfet_01v8_lvt ad=6 pd=8 as=5.7 ps=13.9 w=6 l=1
X87 v g20 sp v sky130_fd_pr__pfet_01v8 ad=0.73 pd=3.46 as=0.5 ps=2 w=1 l=2
X88 sp vb v v sky130_fd_pr__pfet_01v8 ad=0.5 pd=2 as=0.73 ps=3.46 w=1 l=2
X89 v g15 sn v sky130_fd_pr__pfet_01v8 ad=0.5 pd=2 as=0.5 ps=2 w=1 l=2
X90 v g20 sp v sky130_fd_pr__pfet_01v8 ad=0.5 pd=2 as=0.5 ps=2 w=1 l=2
X91 sp g15 v v sky130_fd_pr__pfet_01v8 ad=0.5 pd=2 as=0.5 ps=2 w=1 l=2
X92 sp g15 v v sky130_fd_pr__pfet_01v8 ad=0.5 pd=2 as=0.73 ps=3.46 w=1 l=2
X93 v g20 sn v sky130_fd_pr__pfet_01v8 ad=0.5 pd=2 as=0.5 ps=2 w=1 l=2
X94 v g20 sp v sky130_fd_pr__pfet_01v8 ad=0.73 pd=3.46 as=0.5 ps=2 w=1 l=2
X95 v g a_3306_8498# v sky130_fd_pr__pfet_01v8 ad=0.3486 pd=2.5 as=0.3486 ps=2.5 w=0.42 l=12
X96 sp g15 v v sky130_fd_pr__pfet_01v8 ad=0.5 pd=2 as=0.5 ps=2 w=1 l=2
X97 sn g4 v v sky130_fd_pr__pfet_01v8 ad=0.5 pd=2 as=0.5 ps=2 w=1 l=2
X98 sp g20 v v sky130_fd_pr__pfet_01v8 ad=0.5 pd=2 as=0.73 ps=3.46 w=1 l=2
X99 v g20 sn v sky130_fd_pr__pfet_01v8 ad=0.5 pd=2 as=0.5 ps=2 w=1 l=2
X100 g b1 a_11130_8456# g sky130_fd_pr__nfet_01v8 ad=0.3486 pd=2.5 as=0.3486 ps=2.5 w=0.42 l=0.15
X101 v g4 sn v sky130_fd_pr__pfet_01v8 ad=0.5 pd=2 as=0.5 ps=2 w=1 l=2
X102 v vb vb v sky130_fd_pr__pfet_01v8 ad=1.66 pd=5.66 as=1.66 ps=5.66 w=2 l=2
X103 vb a_8100_8456# g4 v sky130_fd_pr__pfet_01v8 ad=0.6972 pd=3.34 as=0.6972 ps=3.34 w=0.84 l=0.15
X104 sn g15 v v sky130_fd_pr__pfet_01v8 ad=0.5 pd=2 as=0.5 ps=2 w=1 l=2
X105 sp g20 v v sky130_fd_pr__pfet_01v8 ad=0.5 pd=2 as=0.5 ps=2 w=1 l=2
X106 sp g20 v v sky130_fd_pr__pfet_01v8 ad=0.5 pd=2 as=0.73 ps=3.46 w=1 l=2
X107 v g15 sp v sky130_fd_pr__pfet_01v8 ad=0.5 pd=2 as=0.5 ps=2 w=1 l=2
X108 v g15 sn v sky130_fd_pr__pfet_01v8 ad=0.5 pd=2 as=0.5 ps=2 w=1 l=2
X109 sp g20 v v sky130_fd_pr__pfet_01v8 ad=0.5 pd=2 as=0.5 ps=2 w=1 l=2
X110 v a_8100_8456# a_8706_8456# v sky130_fd_pr__pfet_01v8 ad=0.6972 pd=3.34 as=0.6972 ps=3.34 w=0.84 l=0.15
X111 sn g20 v v sky130_fd_pr__pfet_01v8 ad=0.5 pd=2 as=0.5 ps=2 w=1 l=2
X112 rn vinp sn sn sky130_fd_pr__pfet_01v8_lvt ad=5.7 pd=13.9 as=6 ps=8 w=6 l=1
X113 sp g4 v v sky130_fd_pr__pfet_01v8 ad=0.5 pd=2 as=0.5 ps=2 w=1 l=2
X114 v g15 sp v sky130_fd_pr__pfet_01v8 ad=0.5 pd=2 as=0.5 ps=2 w=1 l=2
X115 v b0 a_10524_8456# v sky130_fd_pr__pfet_01v8 ad=0.6972 pd=3.34 as=0.6972 ps=3.34 w=0.84 l=0.15
X116 v g20 sn v sky130_fd_pr__pfet_01v8 ad=0.5 pd=2 as=0.5 ps=2 w=1 l=2
X117 sn g20 v v sky130_fd_pr__pfet_01v8 ad=0.5 pd=2 as=0.5 ps=2 w=1 l=2
X118 sp g15 v v sky130_fd_pr__pfet_01v8 ad=0.5 pd=2 as=0.5 ps=2 w=1 l=2
X119 v g20 sp v sky130_fd_pr__pfet_01v8 ad=0.5 pd=2 as=0.5 ps=2 w=1 l=2
X120 v g20 sn v sky130_fd_pr__pfet_01v8 ad=0.5 pd=2 as=0.5 ps=2 w=1 l=2
X121 g a_2330_8340# a_3306_8498# g sky130_fd_pr__nfet_01v8_lvt ad=4.15 pd=11.66 as=4.15 ps=11.66 w=5 l=0.15
X122 g a_6282_8456# a_8100_8456# g sky130_fd_pr__nfet_01v8 ad=0.3486 pd=2.5 as=0.3486 ps=2.5 w=0.42 l=0.15
X123 sn g15 v v sky130_fd_pr__pfet_01v8 ad=0.5 pd=2 as=0.5 ps=2 w=1 l=2
X124 sn vinp rn sn sky130_fd_pr__pfet_01v8_lvt ad=6 pd=8 as=5.7 ps=13.9 w=6 l=1
X125 sp g20 v v sky130_fd_pr__pfet_01v8 ad=0.5 pd=2 as=0.5 ps=2 w=1 l=2
X126 v g20 sp v sky130_fd_pr__pfet_01v8 ad=0.5 pd=2 as=0.5 ps=2 w=1 l=2
X127 v b1 a_6888_8456# v sky130_fd_pr__pfet_01v8 ad=0.6972 pd=3.34 as=0.6972 ps=3.34 w=0.84 l=0.15
X128 g b0 a_6282_8456# g sky130_fd_pr__nfet_01v8 ad=0.3486 pd=2.5 as=0.3486 ps=2.5 w=0.42 l=0.15
X129 v g4 sp v sky130_fd_pr__pfet_01v8 ad=0.5 pd=2 as=0.5 ps=2 w=1 l=2
X130 sn g15 v v sky130_fd_pr__pfet_01v8 ad=0.5 pd=2 as=0.5 ps=2 w=1 l=2
X131 sp g20 v v sky130_fd_pr__pfet_01v8 ad=0.5 pd=2 as=0.5 ps=2 w=1 l=2
X132 g a_12342_8456# a_12948_8456# g sky130_fd_pr__nfet_01v8 ad=0.3486 pd=2.5 as=0.3486 ps=2.5 w=0.42 l=0.15
X133 v a_12948_8456# g15 v sky130_fd_pr__pfet_01v8 ad=0.6972 pd=3.34 as=0.6972 ps=3.34 w=0.84 l=0.15
X134 v g15 sp v sky130_fd_pr__pfet_01v8 ad=0.5 pd=2 as=0.5 ps=2 w=1 l=2
X135 sn g20 v v sky130_fd_pr__pfet_01v8 ad=0.5 pd=2 as=0.5 ps=2 w=1 l=2
C0 b0 vinp 0.07163f
C1 rs vb 0.7992f
C2 a_13554_8456# b1 0.06253f
C3 a_9918_8456# mid 0.00184f
C4 v b1 2.57854f
C5 a_7494_8456# vb 0.05398f
C6 a_11736_8456# b1 0.143f
C7 a_13554_8456# g4 0.2135f
C8 a_8706_8456# rn 0.30173f
C9 v g4 9.07045f
C10 a_6888_8456# g20 0.14065f
C11 a_11736_8456# g4 0
C12 g15 b1 0.17892f
C13 sp vinp 0.5054f
C14 a_3306_8498# rn 0.06495f
C15 rs refmid 2.03919f
C16 g15 g4 6.3911f
C17 refmid a_7494_8456# 0.00941f
C18 sn a_10524_8456# 0
C19 rp vinn 1.48577f
C20 a_12342_8456# rp 0
C21 vb rn 0.02519f
C22 a_11130_8456# a_2330_8340# 1.99275f
C23 b0 rs 0.3176f
C24 b0 a_7494_8456# 0.23934f
C25 a_6888_8456# a_8100_8456# 0.73959f
C26 a_11130_8456# a_10524_8456# 0.01206f
C27 a_6888_8456# a_12948_8456# 0.1005f
C28 a_6888_8456# a_8706_8456# 0.21919f
C29 rs sp 0.68499f
C30 refmid rn 0
C31 sn vinp 4.73931f
C32 sp a_7494_8456# 0
C33 a_12342_8456# mid 0.01523f
C34 a_6282_8456# b1 0.1921f
C35 v a_13554_8456# 0.56189f
C36 a_6888_8456# a_3306_8498# 0.16369f
C37 g20 a_9312_8456# 0.10573f
C38 b0 rn 0.10543f
C39 a_11130_8456# vinp 0
C40 v a_11736_8456# 0.72092f
C41 a_6282_8456# g4 0.5746f
C42 a_9918_8456# b1 0.56176f
C43 a_6888_8456# vb 0.37263f
C44 g15 a_13554_8456# 0.12361f
C45 g15 v 32.2776f
C46 a_9918_8456# g4 0.26258f
C47 g15 a_11736_8456# 0.00339f
C48 sp rn 2.04952f
C49 a_8100_8456# a_9312_8456# 0
C50 rs sn 0.03088f
C51 sn a_7494_8456# 0.00121f
C52 a_6888_8456# refmid 0.00722f
C53 rs a_11130_8456# 0.02896f
C54 a_8706_8456# a_9312_8456# 0.00446f
C55 g20 rp 0.00826f
C56 b0 a_6888_8456# 0.08103f
C57 a_3306_8498# a_9312_8456# 0
C58 a_13554_8456# a_6282_8456# 0.13304f
C59 vinp a_2330_8340# 0
C60 v a_6282_8456# 1.23011f
C61 sn rn 2.27085f
C62 a_11736_8456# a_6282_8456# 0
C63 vb a_9312_8456# 0.00353f
C64 a_12342_8456# b1 0.08835f
C65 b1 vinn 0.05966f
C66 a_9918_8456# a_13554_8456# 0.26028f
C67 a_6888_8456# sp 0
C68 v a_9918_8456# 1.31764f
C69 a_11130_8456# rn 0.04544f
C70 a_8100_8456# rp 0.00268f
C71 a_12948_8456# rp 0.18061f
C72 g20 mid 1.3997f
C73 a_12342_8456# g4 0.44749f
C74 g4 vinn 0.07648f
C75 a_9918_8456# a_11736_8456# 0.01674f
C76 g15 a_6282_8456# 0.2019f
C77 g15 a_9918_8456# 0.31195f
C78 a_8706_8456# rp 0.31426f
C79 refmid a_9312_8456# 0.00929f
C80 rs a_2330_8340# 0.65414f
C81 a_3306_8498# rp 0.03133f
C82 b0 a_9312_8456# 0.19924f
C83 a_8100_8456# mid 0.00132f
C84 rs a_10524_8456# 0.00369f
C85 sn a_6888_8456# 0
C86 vb rp 0.02655f
C87 a_8706_8456# mid 0.00132f
C88 a_11130_8456# a_6888_8456# 0.23643f
C89 sp a_9312_8456# 0
C90 a_3306_8498# mid 0.00318f
C91 a_13554_8456# vinn 0.04528f
C92 a_12342_8456# a_13554_8456# 3.20718f
C93 a_2330_8340# rn 0.04936f
C94 v vinn 0.37522f
C95 a_12342_8456# v 0.96773f
C96 rs vinp 0.09996f
C97 a_9918_8456# a_6282_8456# 0.25184f
C98 a_12342_8456# a_11736_8456# 0.02634f
C99 refmid rp 0.0144f
C100 vb mid 0.8624f
C101 b0 rp 0.19018f
C102 g15 vinn 0.06603f
C103 a_12342_8456# g15 0.35081f
C104 g20 b1 0.20681f
C105 g20 g4 2.95178f
C106 sn a_9312_8456# 0
C107 refmid mid 1.72901f
C108 vinp rn 1.53051f
C109 sp rp 2.35378f
C110 rs a_7494_8456# 0.00383f
C111 a_8100_8456# b1 0.34361f
C112 b0 mid 0.30159f
C113 a_6888_8456# a_2330_8340# 0.27334f
C114 a_12948_8456# b1 2.96184f
C115 a_8100_8456# g4 0.45553f
C116 a_6888_8456# a_10524_8456# 0
C117 a_12948_8456# g4 0.26983f
C118 a_8706_8456# b1 0.2308f
C119 a_6282_8456# vinn 0.01742f
C120 a_12342_8456# a_6282_8456# 0.20388f
C121 sp mid 0.5778f
C122 a_8706_8456# g4 0.42069f
C123 a_3306_8498# b1 0.22723f
C124 rs rn 0.22883f
C125 a_9918_8456# vinn 0.06059f
C126 a_12342_8456# a_9918_8456# 0.49646f
C127 a_3306_8498# g4 1.53845f
C128 sn rp 0.66594f
C129 g20 a_13554_8456# 0.24561f
C130 a_6888_8456# vinp 0.003f
C131 v g20 42.3978f
C132 vb b1 0.31841f
C133 g20 a_11736_8456# 0.04288f
C134 vb g4 2.90237f
C135 g15 g20 7.11139f
C136 a_13554_8456# a_8100_8456# 2.40825f
C137 a_9312_8456# a_10524_8456# 0.03048f
C138 v a_8100_8456# 1.06036f
C139 a_12948_8456# a_13554_8456# 0.17935f
C140 sn mid 1.37808f
C141 refmid b1 0.39044f
C142 v a_12948_8456# 0.61865f
C143 a_11736_8456# a_8100_8456# 0
C144 a_12948_8456# a_11736_8456# 0.01185f
C145 refmid g4 0.32959f
C146 a_11130_8456# mid 0.00119f
C147 rs a_6888_8456# 0.20561f
C148 b0 b1 4.06458f
C149 a_13554_8456# a_8706_8456# 0.2021f
C150 a_6888_8456# a_7494_8456# 0
C151 v a_8706_8456# 1.27381f
C152 g15 a_8100_8456# 0.20352f
C153 g15 a_12948_8456# 0.33448f
C154 b0 g4 0.08032f
C155 a_11736_8456# a_8706_8456# 0.00169f
C156 a_3306_8498# a_13554_8456# 0.14223f
C157 a_12342_8456# vinn 0.00374f
C158 v a_3306_8498# 1.30253f
C159 a_3306_8498# a_11736_8456# 0
C160 g15 a_8706_8456# 3.19309f
C161 sp b1 0.00101f
C162 g20 a_6282_8456# 0.20378f
C163 a_13554_8456# vb 0.93149f
C164 a_2330_8340# rp 0.07813f
C165 v vb 8.5991f
C166 sp g4 1.92755f
C167 g15 a_3306_8498# 0.13873f
C168 a_6888_8456# rn 0.08834f
C169 g20 a_9918_8456# 0.38423f
C170 g15 vb 0.73235f
C171 a_8100_8456# a_6282_8456# 0.79762f
C172 refmid a_13554_8456# 0
C173 a_12948_8456# a_6282_8456# 0.13979f
C174 rs a_9312_8456# 0.00398f
C175 v refmid 2.95659f
C176 a_7494_8456# a_9312_8456# 0
C177 refmid a_11736_8456# 0.02537f
C178 b0 a_13554_8456# 0.00754f
C179 a_9918_8456# a_8100_8456# 0.26294f
C180 sn b1 0.0038f
C181 mid a_10524_8456# 0.04855f
C182 vinp rp 0.4359f
C183 b0 v 3.33312f
C184 a_12948_8456# a_9918_8456# 3.73471f
C185 a_6282_8456# a_8706_8456# 0.28878f
C186 b0 a_11736_8456# 0.21259f
C187 sn g4 2.17744f
C188 g15 refmid 0.72459f
C189 a_11130_8456# b1 0.30581f
C190 a_3306_8498# a_6282_8456# 3.20703f
C191 a_9918_8456# a_8706_8456# 4.1097f
C192 a_11130_8456# g4 0.2297f
C193 g15 b0 0.08962f
C194 sp a_13554_8456# 0
C195 v sp 14.6072f
C196 a_3306_8498# a_9918_8456# 0.15066f
C197 a_6282_8456# vb 0.35162f
C198 sp a_11736_8456# 0
C199 a_12342_8456# g20 0.2024f
C200 g20 vinn 0.21486f
C201 rs rp 0.66439f
C202 a_9918_8456# vb 0.53498f
C203 g15 sp 2.46873f
C204 refmid a_6282_8456# 0.00894f
C205 a_12342_8456# a_8100_8456# 0.38889f
C206 a_8100_8456# vinn 0.00141f
C207 sn a_13554_8456# 0
C208 a_12342_8456# a_12948_8456# 0.26072f
C209 a_12948_8456# vinn 0.05971f
C210 b0 a_6282_8456# 0.28941f
C211 a_9918_8456# refmid 0.00879f
C212 sn v 13.9122f
C213 rs mid 0.00292f
C214 a_2330_8340# b1 0.1642f
C215 sn a_11736_8456# 0
C216 a_7494_8456# mid 0.02647f
C217 a_6888_8456# a_9312_8456# 0.00778f
C218 a_11130_8456# a_13554_8456# 0.23831f
C219 rp rn 3.99891f
C220 a_11130_8456# v 0.68278f
C221 a_8706_8456# vinn 0.06058f
C222 a_2330_8340# g4 0.24815f
C223 a_12342_8456# a_8706_8456# 0.41776f
C224 b0 a_9918_8456# 0.10118f
C225 b1 a_10524_8456# 0.15994f
C226 a_11130_8456# a_11736_8456# 0.0077f
C227 g15 sn 2.51384f
C228 g4 a_10524_8456# 0
C229 a_3306_8498# vinn 0.10586f
C230 a_12342_8456# a_3306_8498# 0.22179f
C231 sp a_6282_8456# 0
C232 g15 a_11130_8456# 0.19994f
C233 sp a_9918_8456# 0
C234 a_12342_8456# vb 0.58395f
C235 vb vinn 0.04136f
C236 vinp b1 0.06199f
C237 vinp g4 0.05905f
C238 a_6888_8456# rp 0.01465f
C239 refmid vinn 0
C240 a_12342_8456# refmid 0.01029f
C241 sn a_6282_8456# 0
C242 a_13554_8456# a_2330_8340# 0.2727f
C243 v a_2330_8340# 0.44455f
C244 b0 vinn 0.06934f
C245 a_11130_8456# a_6282_8456# 0.13998f
C246 a_12342_8456# b0 0.00991f
C247 sn a_9918_8456# 0
C248 v a_10524_8456# 0.45176f
C249 rs b1 0.42914f
C250 g20 a_8100_8456# 0.20261f
C251 a_11736_8456# a_10524_8456# 0.03049f
C252 a_12948_8456# g20 0.2285f
C253 a_7494_8456# b1 0.17258f
C254 a_6888_8456# mid 0.00145f
C255 a_11130_8456# a_9918_8456# 0.36302f
C256 g15 a_2330_8340# 0.1985f
C257 rs g4 0.43952f
C258 a_7494_8456# g4 0
C259 g15 a_10524_8456# 0.00227f
C260 g20 a_8706_8456# 0.19952f
C261 a_12342_8456# sp 0
C262 sp vinn 3.28593f
C263 a_13554_8456# vinp 0.00269f
C264 v vinp 0.32198f
C265 a_3306_8498# g20 0.13557f
C266 a_12948_8456# a_8100_8456# 0.18911f
C267 b1 rn 0.11811f
C268 g20 vb 2.28637f
C269 a_8100_8456# a_8706_8456# 0.48492f
C270 g4 rn 0.18152f
C271 g15 vinp 0.06609f
C272 a_12948_8456# a_8706_8456# 0.13597f
C273 a_6282_8456# a_2330_8340# 0.27405f
C274 a_3306_8498# a_8100_8456# 0.22264f
C275 a_3306_8498# a_12948_8456# 0.12855f
C276 sn vinn 0.60481f
C277 a_12342_8456# sn 0
C278 a_6282_8456# a_10524_8456# 0
C279 mid a_9312_8456# 0.02674f
C280 rs a_13554_8456# 0.15882f
C281 rs v 2.99268f
C282 a_9918_8456# a_2330_8340# 0.17538f
C283 a_11130_8456# vinn 0
C284 g20 refmid 0.94802f
C285 a_12342_8456# a_11130_8456# 0.65381f
C286 a_8100_8456# vb 2.18471f
C287 v a_7494_8456# 0.69412f
C288 rs a_11736_8456# 0.00398f
C289 a_3306_8498# a_8706_8456# 0.39464f
C290 a_12948_8456# vb 0.46706f
C291 a_9918_8456# a_10524_8456# 0.00912f
C292 b0 g20 0.16994f
C293 a_6888_8456# b1 0.35291f
C294 g15 rs 0.74989f
C295 vb a_8706_8456# 0.42339f
C296 g15 a_7494_8456# 0.00294f
C297 a_6888_8456# g4 0.19445f
C298 a_6282_8456# vinp 0.00492f
C299 refmid a_8100_8456# 0.0043f
C300 a_12948_8456# refmid 0.0197f
C301 a_3306_8498# vb 0.55748f
C302 a_13554_8456# rn 0.04688f
C303 v rn 0.14386f
C304 g20 sp 3.52797f
C305 a_9918_8456# vinp 0.06619f
C306 b0 a_8100_8456# 0.01923f
C307 b0 a_12948_8456# 0.14042f
C308 refmid a_8706_8456# 0.00505f
C309 g15 rn 0.58656f
C310 b0 a_8706_8456# 0.01957f
C311 a_3306_8498# refmid 0.03796f
C312 a_2330_8340# vinn 0
C313 a_12342_8456# a_2330_8340# 0.27304f
C314 sp a_8100_8456# 0
C315 rs a_6282_8456# 0.23479f
C316 a_12948_8456# sp 0
C317 b0 a_3306_8498# 0.2038f
C318 a_7494_8456# a_6282_8456# 0.00811f
C319 a_12342_8456# a_10524_8456# 0
C320 refmid vb 0.28512f
C321 b1 a_9312_8456# 0.14131f
C322 rs a_9918_8456# 0.45053f
C323 sn g20 3.06528f
C324 sp a_8706_8456# 0
C325 a_6888_8456# a_13554_8456# 0.13357f
C326 g4 a_9312_8456# 0
C327 b0 vb 0.15179f
C328 a_6888_8456# v 0.81724f
C329 a_11130_8456# g20 0.2005f
C330 a_6888_8456# a_11736_8456# 0
C331 a_3306_8498# sp 0
C332 vinp vinn 2.03224f
C333 a_6282_8456# rn 0.1081f
C334 a_12342_8456# vinp 0.00219f
C335 g15 a_6888_8456# 0.13964f
C336 sn a_8100_8456# 0
C337 sp vb 0.60625f
C338 sn a_12948_8456# 0.00118f
C339 b0 refmid 0.34267f
C340 a_9918_8456# rn 0.23336f
C341 a_11130_8456# a_8100_8456# 0.17453f
C342 a_11130_8456# a_12948_8456# 0.16327f
C343 sn a_8706_8456# 0
C344 rp b1 0.17325f
C345 g4 rp 0.00293f
C346 sp refmid 0.92204f
C347 a_11130_8456# a_8706_8456# 0.35931f
C348 a_12342_8456# rs 0.18831f
C349 rs vinn 0.09686f
C350 v a_9312_8456# 0.80773f
C351 b0 sp 0.00118f
C352 a_11130_8456# a_3306_8498# 0.15959f
C353 a_11736_8456# a_9312_8456# 0
C354 sn vb 0.47371f
C355 g20 a_2330_8340# 0.25118f
C356 a_6888_8456# a_6282_8456# 3.92935f
C357 mid b1 0.01357f
C358 g20 a_10524_8456# 0.02036f
C359 a_11130_8456# vb 1.05703f
C360 g15 a_9312_8456# 0.02411f
C361 g4 mid 0.25673f
C362 a_6888_8456# a_9918_8456# 0.27309f
C363 sn refmid 1.36418f
C364 rn vinn 0.60548f
C365 a_12342_8456# rn 0.12033f
C366 a_8100_8456# a_2330_8340# 0.30146f
C367 a_12948_8456# a_2330_8340# 0.16341f
C368 a_8100_8456# a_10524_8456# 0
C369 a_11130_8456# refmid 0.00441f
C370 b0 sn 0.00391f
C371 g20 vinp 0.10788f
C372 a_13554_8456# rp 0
C373 v rp 0.01045f
C374 a_8706_8456# a_2330_8340# 0.18789f
C375 b0 a_11130_8456# 0.09111f
C376 a_8706_8456# a_10524_8456# 0.00169f
C377 a_3306_8498# a_2330_8340# 0.41953f
C378 a_6282_8456# a_9312_8456# 0.00784f
C379 sn sp 4.66862f
C380 g15 rp 0.01842f
C381 a_3306_8498# a_10524_8456# 0
C382 a_8100_8456# vinp 0
C383 a_12948_8456# vinp 0.0621f
C384 a_11130_8456# sp 0
C385 a_9918_8456# a_9312_8456# 0.03011f
C386 vb a_2330_8340# 4.85285f
C387 v mid 3.42362f
C388 a_6888_8456# vinn 0.0064f
C389 a_12342_8456# a_6888_8456# 2.78839f
C390 a_11736_8456# mid 0.12445f
C391 rs g20 1.09465f
C392 g20 a_7494_8456# 0.01095f
C393 a_8706_8456# vinp 0.06384f
C394 g15 mid 0.83988f
C395 g4 b1 0.17539f
C396 a_3306_8498# vinp 0.01022f
C397 refmid a_2330_8340# 0.0039f
C398 refmid a_10524_8456# 0.00859f
C399 rs a_8100_8456# 0.22211f
C400 rs a_12948_8456# 0.409f
C401 a_6282_8456# rp 0.0153f
C402 b0 a_2330_8340# 0.15945f
C403 vb vinp 0.02558f
C404 a_7494_8456# a_8100_8456# 0.01271f
C405 sn a_11130_8456# 0
C406 g20 rn 0.29301f
C407 b0 a_10524_8456# 0.37728f
C408 a_9918_8456# rp 0.29466f
C409 rs a_8706_8456# 0.34012f
C410 a_7494_8456# a_8706_8456# 0.0117f
C411 sp a_2330_8340# 0
C412 rs a_3306_8498# 0.43515f
C413 refmid vinp 0
C414 a_3306_8498# a_7494_8456# 0.00153f
C415 a_6282_8456# mid 0.00221f
C416 sp a_10524_8456# 0
C417 a_8100_8456# rn 0.05758f
C418 a_12948_8456# rn 0.21247f
C419 vinp g 1.49594f
C420 vinn g 2.1241f
C421 rn g 49.7493f
C422 rp g 49.6432f
C423 b1 g 2.69419f
C424 b0 g 3.77279f
C425 v g 0.3401p
C426 mid g 6.1992f ; **FLOATING
C427 refmid g 5.12133f ; **FLOATING
C428 rs g 4.11688f ; **FLOATING
C429 g20 g 4.51208f ; **FLOATING
C430 g15 g 4.31655f ; **FLOATING
C431 g4 g 3.31104f ; **FLOATING
C432 a_11736_8456# g 0.11469f ; **FLOATING
C433 a_10524_8456# g 0.06739f ; **FLOATING
C434 a_9312_8456# g 0.21585f ; **FLOATING
C435 a_7494_8456# g 0.08256f ; **FLOATING
C436 a_3306_8498# g 3.39589f ; **FLOATING
C437 a_13554_8456# g 2.95172f ; **FLOATING
C438 a_12948_8456# g 2.1063f ; **FLOATING
C439 a_8706_8456# g 1.66197f ; **FLOATING
C440 a_12342_8456# g 3.86487f ; **FLOATING
C441 a_9918_8456# g 2.46522f ; **FLOATING
C442 a_11130_8456# g 7.75529f ; **FLOATING
C443 a_6888_8456# g 3.25717f ; **FLOATING
C444 a_8100_8456# g 5.3548f ; **FLOATING
C445 a_6282_8456# g 3.3756f ; **FLOATING
C446 vb g 12.5045f ; **FLOATING
C447 a_2330_8340# g 6.81746f ; **FLOATING
C448 sn g 21.7171f ; **FLOATING
C449 sp g 21.8604f ; **FLOATING
.ends
