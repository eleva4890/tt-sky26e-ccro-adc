* Route Verilog connectivity + foundry standard-cell schematics
.subckt sky130_fd_sc_hd__a21boi_1 A1 A2 B1_N VGND VNB VPB VPWR Y
X0 a_384_47# A2 VGND VNB sky130_fd_pr__nfet_01v8 w=650000u l=150000u
X1 VGND a_27_413# Y VNB sky130_fd_pr__nfet_01v8 w=650000u l=150000u
X2 a_300_297# A1 VPWR VPB sky130_fd_pr__pfet_01v8_hvt w=1e+06u l=150000u
X3 Y a_27_413# a_300_297# VPB sky130_fd_pr__pfet_01v8_hvt w=1e+06u l=150000u
X4 a_27_413# B1_N VGND VNB sky130_fd_pr__nfet_01v8 w=420000u l=150000u
X5 Y A1 a_384_47# VNB sky130_fd_pr__nfet_01v8 w=650000u l=150000u
X6 a_27_413# B1_N VPWR VPB sky130_fd_pr__pfet_01v8_hvt w=420000u l=150000u
X7 VPWR A2 a_300_297# VPB sky130_fd_pr__pfet_01v8_hvt w=1e+06u l=150000u
.ends
.subckt sky130_fd_sc_hd__a21o_1 A1 A2 B1 VGND VNB VPB VPWR X
X0 a_384_47# A2 VGND VNB sky130_fd_pr__nfet_01v8 w=650000u l=150000u
X1 X a_81_21# VPWR VPB sky130_fd_pr__pfet_01v8_hvt w=1e+06u l=150000u
X2 a_81_21# B1 a_299_297# VPB sky130_fd_pr__pfet_01v8_hvt w=1e+06u l=150000u
X3 VGND B1 a_81_21# VNB sky130_fd_pr__nfet_01v8 w=650000u l=150000u
X4 a_299_297# A1 VPWR VPB sky130_fd_pr__pfet_01v8_hvt w=1e+06u l=150000u
X5 VPWR A2 a_299_297# VPB sky130_fd_pr__pfet_01v8_hvt w=1e+06u l=150000u
X6 X a_81_21# VGND VNB sky130_fd_pr__nfet_01v8 w=650000u l=150000u
X7 a_81_21# A1 a_384_47# VNB sky130_fd_pr__nfet_01v8 w=650000u l=150000u
.ends
.subckt sky130_fd_sc_hd__a21oi_1 A1 A2 B1 VGND VNB VPB VPWR Y
X0 a_199_47# A2 VGND VNB sky130_fd_pr__nfet_01v8 w=650000u l=150000u
X1 a_113_297# A1 VPWR VPB sky130_fd_pr__pfet_01v8_hvt w=1e+06u l=150000u
X2 Y B1 a_113_297# VPB sky130_fd_pr__pfet_01v8_hvt w=1e+06u l=150000u
X3 VGND B1 Y VNB sky130_fd_pr__nfet_01v8 w=650000u l=150000u
X4 VPWR A2 a_113_297# VPB sky130_fd_pr__pfet_01v8_hvt w=1e+06u l=150000u
X5 Y A1 a_199_47# VNB sky130_fd_pr__nfet_01v8 w=650000u l=150000u
.ends
.subckt sky130_fd_sc_hd__a21oi_4 A1 A2 B1 VGND VNB VPB VPWR Y
X0 VGND A2 a_462_47# VNB sky130_fd_pr__nfet_01v8 w=650000u l=150000u
X1 Y B1 a_28_297# VPB sky130_fd_pr__pfet_01v8_hvt w=1e+06u l=150000u
X2 a_28_297# A2 VPWR VPB sky130_fd_pr__pfet_01v8_hvt w=1e+06u l=150000u
X3 Y B1 VGND VNB sky130_fd_pr__nfet_01v8 w=650000u l=150000u
X4 a_28_297# A1 VPWR VPB sky130_fd_pr__pfet_01v8_hvt w=1e+06u l=150000u
X5 a_28_297# B1 Y VPB sky130_fd_pr__pfet_01v8_hvt w=1e+06u l=150000u
X6 VPWR A1 a_28_297# VPB sky130_fd_pr__pfet_01v8_hvt w=1e+06u l=150000u
X7 VPWR A1 a_28_297# VPB sky130_fd_pr__pfet_01v8_hvt w=1e+06u l=150000u
X8 VGND B1 Y VNB sky130_fd_pr__nfet_01v8 w=650000u l=150000u
X9 Y B1 a_28_297# VPB sky130_fd_pr__pfet_01v8_hvt w=1e+06u l=150000u
X10 a_28_297# B1 Y VPB sky130_fd_pr__pfet_01v8_hvt w=1e+06u l=150000u
X11 VPWR A2 a_28_297# VPB sky130_fd_pr__pfet_01v8_hvt w=1e+06u l=150000u
X12 a_28_297# A2 VPWR VPB sky130_fd_pr__pfet_01v8_hvt w=1e+06u l=150000u
X13 a_462_47# A1 Y VNB sky130_fd_pr__nfet_01v8 w=650000u l=150000u
X14 a_28_297# A1 VPWR VPB sky130_fd_pr__pfet_01v8_hvt w=1e+06u l=150000u
X15 VPWR A2 a_28_297# VPB sky130_fd_pr__pfet_01v8_hvt w=1e+06u l=150000u
X16 VGND A2 a_462_47# VNB sky130_fd_pr__nfet_01v8 w=650000u l=150000u
X17 a_462_47# A2 VGND VNB sky130_fd_pr__nfet_01v8 w=650000u l=150000u
X18 Y A1 a_462_47# VNB sky130_fd_pr__nfet_01v8 w=650000u l=150000u
X19 a_462_47# A2 VGND VNB sky130_fd_pr__nfet_01v8 w=650000u l=150000u
X20 Y B1 VGND VNB sky130_fd_pr__nfet_01v8 w=650000u l=150000u
X21 VGND B1 Y VNB sky130_fd_pr__nfet_01v8 w=650000u l=150000u
X22 a_462_47# A1 Y VNB sky130_fd_pr__nfet_01v8 w=650000u l=150000u
X23 Y A1 a_462_47# VNB sky130_fd_pr__nfet_01v8 w=650000u l=150000u
.ends
.subckt sky130_fd_sc_hd__a22o_1 A1 A2 B1 B2 VGND VNB VPB VPWR X
X0 a_109_297# A2 VPWR VPB sky130_fd_pr__pfet_01v8_hvt w=1e+06u l=150000u
X1 VPWR A1 a_109_297# VPB sky130_fd_pr__pfet_01v8_hvt w=1e+06u l=150000u
X2 a_373_47# A2 VGND VNB sky130_fd_pr__nfet_01v8 w=650000u l=150000u
X3 a_109_47# B1 a_27_297# VNB sky130_fd_pr__nfet_01v8 w=650000u l=150000u
X4 VGND a_27_297# X VNB sky130_fd_pr__nfet_01v8 w=650000u l=150000u
X5 a_27_297# A1 a_373_47# VNB sky130_fd_pr__nfet_01v8 w=650000u l=150000u
X6 VPWR a_27_297# X VPB sky130_fd_pr__pfet_01v8_hvt w=1e+06u l=150000u
X7 VGND B2 a_109_47# VNB sky130_fd_pr__nfet_01v8 w=650000u l=150000u
X8 a_27_297# B2 a_109_297# VPB sky130_fd_pr__pfet_01v8_hvt w=1e+06u l=150000u
X9 a_109_297# B1 a_27_297# VPB sky130_fd_pr__pfet_01v8_hvt w=1e+06u l=150000u
.ends
.subckt sky130_fd_sc_hd__a22o_2 A1 A2 B1 B2 VGND VNB VPB VPWR X
X0 VPWR a_27_297# X VPB sky130_fd_pr__pfet_01v8_hvt w=1e+06u l=150000u
X1 a_109_297# A2 VPWR VPB sky130_fd_pr__pfet_01v8_hvt w=1e+06u l=150000u
X2 a_109_47# B1 a_27_297# VNB sky130_fd_pr__nfet_01v8 w=650000u l=150000u
X3 VPWR A1 a_109_297# VPB sky130_fd_pr__pfet_01v8_hvt w=1e+06u l=150000u
X4 X a_27_297# VGND VNB sky130_fd_pr__nfet_01v8 w=650000u l=150000u
X5 VGND a_27_297# X VNB sky130_fd_pr__nfet_01v8 w=650000u l=150000u
X6 VGND B2 a_109_47# VNB sky130_fd_pr__nfet_01v8 w=650000u l=150000u
X7 a_27_297# B2 a_109_297# VPB sky130_fd_pr__pfet_01v8_hvt w=1e+06u l=150000u
X8 a_27_297# A1 a_381_47# VNB sky130_fd_pr__nfet_01v8 w=650000u l=150000u
X9 a_109_297# B1 a_27_297# VPB sky130_fd_pr__pfet_01v8_hvt w=1e+06u l=150000u
X10 a_381_47# A2 VGND VNB sky130_fd_pr__nfet_01v8 w=650000u l=150000u
X11 X a_27_297# VPWR VPB sky130_fd_pr__pfet_01v8_hvt w=1e+06u l=150000u
.ends
.subckt sky130_fd_sc_hd__a22oi_1 A1 A2 B1 B2 VGND VNB VPB VPWR Y
X0 a_109_47# B1 Y VNB sky130_fd_pr__nfet_01v8 w=650000u l=150000u
X1 a_109_297# A2 VPWR VPB sky130_fd_pr__pfet_01v8_hvt w=1e+06u l=150000u
X2 VPWR A1 a_109_297# VPB sky130_fd_pr__pfet_01v8_hvt w=1e+06u l=150000u
X3 a_381_47# A2 VGND VNB sky130_fd_pr__nfet_01v8 w=650000u l=150000u
X4 VGND B2 a_109_47# VNB sky130_fd_pr__nfet_01v8 w=650000u l=150000u
X5 Y B2 a_109_297# VPB sky130_fd_pr__pfet_01v8_hvt w=1e+06u l=150000u
X6 Y A1 a_381_47# VNB sky130_fd_pr__nfet_01v8 w=650000u l=150000u
X7 a_109_297# B1 Y VPB sky130_fd_pr__pfet_01v8_hvt w=1e+06u l=150000u
.ends
.subckt sky130_fd_sc_hd__a31oi_1 A1 A2 A3 B1 VGND VNB VPB VPWR Y
X0 a_109_297# B1 Y VPB sky130_fd_pr__pfet_01v8_hvt w=1e+06u l=150000u
X1 a_181_47# A1 Y VNB sky130_fd_pr__nfet_01v8 w=650000u l=150000u
X2 VPWR A1 a_109_297# VPB sky130_fd_pr__pfet_01v8_hvt w=1e+06u l=150000u
X3 a_109_47# A2 a_181_47# VNB sky130_fd_pr__nfet_01v8 w=650000u l=150000u
X4 Y B1 VGND VNB sky130_fd_pr__nfet_01v8 w=650000u l=150000u
X5 VGND A3 a_109_47# VNB sky130_fd_pr__nfet_01v8 w=650000u l=150000u
X6 VPWR A3 a_109_297# VPB sky130_fd_pr__pfet_01v8_hvt w=1e+06u l=150000u
X7 a_109_297# A2 VPWR VPB sky130_fd_pr__pfet_01v8_hvt w=1e+06u l=150000u
.ends
.subckt sky130_fd_sc_hd__and2_0 A B VGND VNB VPB VPWR X
X0 a_40_47# B VPWR VPB sky130_fd_pr__pfet_01v8_hvt w=420000u l=150000u
X1 a_123_47# B VGND VNB sky130_fd_pr__nfet_01v8 w=420000u l=150000u
X2 a_40_47# A a_123_47# VNB sky130_fd_pr__nfet_01v8 w=420000u l=150000u
X3 VGND a_40_47# X VNB sky130_fd_pr__nfet_01v8 w=420000u l=150000u
X4 VPWR A a_40_47# VPB sky130_fd_pr__pfet_01v8_hvt w=420000u l=150000u
X5 VPWR a_40_47# X VPB sky130_fd_pr__pfet_01v8_hvt w=640000u l=150000u
.ends
.subckt sky130_fd_sc_hd__and2_1 A B VGND VNB VPB VPWR X
X0 VGND a_59_75# X VNB sky130_fd_pr__nfet_01v8 w=650000u l=150000u
X1 VPWR A a_59_75# VPB sky130_fd_pr__pfet_01v8_hvt w=420000u l=150000u
X2 a_59_75# A a_145_75# VNB sky130_fd_pr__nfet_01v8 w=420000u l=150000u
X3 a_59_75# B VPWR VPB sky130_fd_pr__pfet_01v8_hvt w=420000u l=150000u
X4 a_145_75# B VGND VNB sky130_fd_pr__nfet_01v8 w=420000u l=150000u
X5 VPWR a_59_75# X VPB sky130_fd_pr__pfet_01v8_hvt w=1e+06u l=150000u
.ends
.subckt sky130_fd_sc_hd__and2_2 A B VGND VNB VPB VPWR X
X0 VPWR a_61_75# X VPB sky130_fd_pr__pfet_01v8_hvt w=1e+06u l=150000u
X1 VPWR A a_61_75# VPB sky130_fd_pr__pfet_01v8_hvt w=420000u l=150000u
X2 a_147_75# B VGND VNB sky130_fd_pr__nfet_01v8 w=420000u l=150000u
X3 a_61_75# B VPWR VPB sky130_fd_pr__pfet_01v8_hvt w=420000u l=150000u
X4 VGND a_61_75# X VNB sky130_fd_pr__nfet_01v8 w=650000u l=150000u
X5 X a_61_75# VGND VNB sky130_fd_pr__nfet_01v8 w=650000u l=150000u
X6 a_61_75# A a_147_75# VNB sky130_fd_pr__nfet_01v8 w=420000u l=150000u
X7 X a_61_75# VPWR VPB sky130_fd_pr__pfet_01v8_hvt w=1e+06u l=150000u
.ends
.subckt sky130_fd_sc_hd__and3_1 A B C VGND VNB VPB VPWR X
X0 a_181_47# C VGND VNB sky130_fd_pr__nfet_01v8 w=420000u l=150000u
X1 a_27_47# A VPWR VPB sky130_fd_pr__pfet_01v8_hvt w=420000u l=150000u
X2 VPWR B a_27_47# VPB sky130_fd_pr__pfet_01v8_hvt w=420000u l=150000u
X3 VPWR a_27_47# X VPB sky130_fd_pr__pfet_01v8_hvt w=1e+06u l=150000u
X4 a_109_47# B a_181_47# VNB sky130_fd_pr__nfet_01v8 w=420000u l=150000u
X5 a_27_47# A a_109_47# VNB sky130_fd_pr__nfet_01v8 w=420000u l=150000u
X6 VGND a_27_47# X VNB sky130_fd_pr__nfet_01v8 w=650000u l=150000u
X7 a_27_47# C VPWR VPB sky130_fd_pr__pfet_01v8_hvt w=420000u l=150000u
.ends
.subckt sky130_fd_sc_hd__and4_1 A B C D VGND VNB VPB VPWR X
X0 a_197_47# C a_303_47# VNB sky130_fd_pr__nfet_01v8 w=420000u l=150000u
X1 a_303_47# D VGND VNB sky130_fd_pr__nfet_01v8 w=420000u l=150000u
X2 VGND a_27_47# X VNB sky130_fd_pr__nfet_01v8 w=650000u l=150000u
X3 a_27_47# D VPWR VPB sky130_fd_pr__pfet_01v8_hvt w=420000u l=150000u
X4 VPWR C a_27_47# VPB sky130_fd_pr__pfet_01v8_hvt w=420000u l=150000u
X5 a_109_47# B a_197_47# VNB sky130_fd_pr__nfet_01v8 w=420000u l=150000u
X6 VPWR a_27_47# X VPB sky130_fd_pr__pfet_01v8_hvt w=1e+06u l=150000u
X7 VPWR A a_27_47# VPB sky130_fd_pr__pfet_01v8_hvt w=420000u l=150000u
X8 a_27_47# B VPWR VPB sky130_fd_pr__pfet_01v8_hvt w=420000u l=150000u
X9 a_27_47# A a_109_47# VNB sky130_fd_pr__nfet_01v8 w=420000u l=150000u
.ends
.subckt sky130_fd_sc_hd__and4_2 A B C D VGND VNB VPB VPWR X
X0 a_27_47# B VPWR VPB sky130_fd_pr__pfet_01v8_hvt w=420000u l=150000u
X1 VGND a_27_47# X VNB sky130_fd_pr__nfet_01v8 w=650000u l=150000u
X2 a_109_47# B a_198_47# VNB sky130_fd_pr__nfet_01v8 w=420000u l=150000u
X3 X a_27_47# VGND VNB sky130_fd_pr__nfet_01v8 w=650000u l=150000u
X4 X a_27_47# VPWR VPB sky130_fd_pr__pfet_01v8_hvt w=1e+06u l=150000u
X5 VPWR C a_27_47# VPB sky130_fd_pr__pfet_01v8_hvt w=420000u l=150000u
X6 VPWR A a_27_47# VPB sky130_fd_pr__pfet_01v8_hvt w=420000u l=150000u
X7 VPWR a_27_47# X VPB sky130_fd_pr__pfet_01v8_hvt w=1e+06u l=150000u
X8 a_27_47# D VPWR VPB sky130_fd_pr__pfet_01v8_hvt w=420000u l=150000u
X9 a_27_47# A a_109_47# VNB sky130_fd_pr__nfet_01v8 w=420000u l=150000u
X10 a_304_47# D VGND VNB sky130_fd_pr__nfet_01v8 w=420000u l=150000u
X11 a_198_47# C a_304_47# VNB sky130_fd_pr__nfet_01v8 w=420000u l=150000u
.ends
.subckt sky130_fd_sc_hd__buf_6 A VGND VNB VPB VPWR X
X0 VGND a_161_47# X VNB sky130_fd_pr__nfet_01v8 w=650000u l=150000u
X1 VGND a_161_47# X VNB sky130_fd_pr__nfet_01v8 w=650000u l=150000u
X2 X a_161_47# VGND VNB sky130_fd_pr__nfet_01v8 w=650000u l=150000u
X3 a_161_47# A VPWR VPB sky130_fd_pr__pfet_01v8_hvt w=1e+06u l=150000u
X4 VPWR A a_161_47# VPB sky130_fd_pr__pfet_01v8_hvt w=1e+06u l=150000u
X5 VGND a_161_47# X VNB sky130_fd_pr__nfet_01v8 w=650000u l=150000u
X6 X a_161_47# VPWR VPB sky130_fd_pr__pfet_01v8_hvt w=1e+06u l=150000u
X7 X a_161_47# VGND VNB sky130_fd_pr__nfet_01v8 w=650000u l=150000u
X8 VPWR a_161_47# X VPB sky130_fd_pr__pfet_01v8_hvt w=1e+06u l=150000u
X9 a_161_47# A VGND VNB sky130_fd_pr__nfet_01v8 w=650000u l=150000u
X10 VPWR a_161_47# X VPB sky130_fd_pr__pfet_01v8_hvt w=1e+06u l=150000u
X11 VPWR a_161_47# X VPB sky130_fd_pr__pfet_01v8_hvt w=1e+06u l=150000u
X12 X a_161_47# VPWR VPB sky130_fd_pr__pfet_01v8_hvt w=1e+06u l=150000u
X13 VGND A a_161_47# VNB sky130_fd_pr__nfet_01v8 w=650000u l=150000u
X14 X a_161_47# VGND VNB sky130_fd_pr__nfet_01v8 w=650000u l=150000u
X15 X a_161_47# VPWR VPB sky130_fd_pr__pfet_01v8_hvt w=1e+06u l=150000u
.ends
.subckt sky130_fd_sc_hd__clkbuf_4 A VGND VNB VPB VPWR X
X0 VPWR a_27_47# X VPB sky130_fd_pr__pfet_01v8_hvt w=1e+06u l=150000u
X1 X a_27_47# VPWR VPB sky130_fd_pr__pfet_01v8_hvt w=1e+06u l=150000u
X2 a_27_47# A VPWR VPB sky130_fd_pr__pfet_01v8_hvt w=1e+06u l=150000u
X3 a_27_47# A VGND VNB sky130_fd_pr__nfet_01v8 w=420000u l=150000u
X4 X a_27_47# VPWR VPB sky130_fd_pr__pfet_01v8_hvt w=1e+06u l=150000u
X5 VGND a_27_47# X VNB sky130_fd_pr__nfet_01v8 w=420000u l=150000u
X6 X a_27_47# VGND VNB sky130_fd_pr__nfet_01v8 w=420000u l=150000u
X7 VGND a_27_47# X VNB sky130_fd_pr__nfet_01v8 w=420000u l=150000u
X8 X a_27_47# VGND VNB sky130_fd_pr__nfet_01v8 w=420000u l=150000u
X9 VPWR a_27_47# X VPB sky130_fd_pr__pfet_01v8_hvt w=1e+06u l=150000u
.ends
.subckt sky130_fd_sc_hd__clkbuf_8 A VGND VNB VPB VPWR X
X0 X a_110_47# VGND VNB sky130_fd_pr__nfet_01v8 w=420000u l=150000u
X1 a_110_47# A VPWR VPB sky130_fd_pr__pfet_01v8_hvt w=1e+06u l=150000u
X2 X a_110_47# VGND VNB sky130_fd_pr__nfet_01v8 w=420000u l=150000u
X3 VPWR A a_110_47# VPB sky130_fd_pr__pfet_01v8_hvt w=1e+06u l=150000u
X4 VGND a_110_47# X VNB sky130_fd_pr__nfet_01v8 w=420000u l=150000u
X5 VGND A a_110_47# VNB sky130_fd_pr__nfet_01v8 w=420000u l=150000u
X6 X a_110_47# VGND VNB sky130_fd_pr__nfet_01v8 w=420000u l=150000u
X7 X a_110_47# VPWR VPB sky130_fd_pr__pfet_01v8_hvt w=1e+06u l=150000u
X8 VPWR a_110_47# X VPB sky130_fd_pr__pfet_01v8_hvt w=1e+06u l=150000u
X9 VPWR a_110_47# X VPB sky130_fd_pr__pfet_01v8_hvt w=1e+06u l=150000u
X10 VGND a_110_47# X VNB sky130_fd_pr__nfet_01v8 w=420000u l=150000u
X11 X a_110_47# VGND VNB sky130_fd_pr__nfet_01v8 w=420000u l=150000u
X12 X a_110_47# VPWR VPB sky130_fd_pr__pfet_01v8_hvt w=1e+06u l=150000u
X13 VPWR a_110_47# X VPB sky130_fd_pr__pfet_01v8_hvt w=1e+06u l=150000u
X14 VPWR a_110_47# X VPB sky130_fd_pr__pfet_01v8_hvt w=1e+06u l=150000u
X15 X a_110_47# VPWR VPB sky130_fd_pr__pfet_01v8_hvt w=1e+06u l=150000u
X16 X a_110_47# VPWR VPB sky130_fd_pr__pfet_01v8_hvt w=1e+06u l=150000u
X17 a_110_47# A VGND VNB sky130_fd_pr__nfet_01v8 w=420000u l=150000u
X18 VGND a_110_47# X VNB sky130_fd_pr__nfet_01v8 w=420000u l=150000u
X19 VGND a_110_47# X VNB sky130_fd_pr__nfet_01v8 w=420000u l=150000u
.ends
.subckt sky130_fd_sc_hd__clkdlybuf4s25_1 A VGND VNB VPB VPWR X
X0 a_355_47# a_244_47# VPWR VPB sky130_fd_pr__pfet_01v8_hvt w=820000u l=250000u
X1 VPWR a_27_47# a_244_47# VPB sky130_fd_pr__pfet_01v8_hvt w=820000u l=250000u
X2 VPWR a_355_47# X VPB sky130_fd_pr__pfet_01v8_hvt w=1e+06u l=150000u
X3 a_27_47# A VPWR VPB sky130_fd_pr__pfet_01v8_hvt w=1e+06u l=150000u
X4 a_355_47# a_244_47# VGND VNB sky130_fd_pr__nfet_01v8 w=650000u l=250000u
X5 VGND a_27_47# a_244_47# VNB sky130_fd_pr__nfet_01v8 w=650000u l=250000u
X6 VGND a_355_47# X VNB sky130_fd_pr__nfet_01v8 w=420000u l=150000u
X7 a_27_47# A VGND VNB sky130_fd_pr__nfet_01v8 w=420000u l=150000u
.ends
.subckt sky130_fd_sc_hd__clkinv_8 A VGND VNB VPB VPWR Y
X0 Y A VPWR VPB sky130_fd_pr__pfet_01v8_hvt w=1e+06u l=150000u
X1 VGND A Y VNB sky130_fd_pr__nfet_01v8 w=420000u l=150000u
X2 Y A VGND VNB sky130_fd_pr__nfet_01v8 w=420000u l=150000u
X3 Y A VPWR VPB sky130_fd_pr__pfet_01v8_hvt w=1e+06u l=150000u
X4 VGND A Y VNB sky130_fd_pr__nfet_01v8 w=420000u l=150000u
X5 Y A VGND VNB sky130_fd_pr__nfet_01v8 w=420000u l=150000u
X6 Y A VPWR VPB sky130_fd_pr__pfet_01v8_hvt w=1e+06u l=150000u
X7 Y A VGND VNB sky130_fd_pr__nfet_01v8 w=420000u l=150000u
X8 Y A VPWR VPB sky130_fd_pr__pfet_01v8_hvt w=1e+06u l=150000u
X9 VGND A Y VNB sky130_fd_pr__nfet_01v8 w=420000u l=150000u
X10 VPWR A Y VPB sky130_fd_pr__pfet_01v8_hvt w=1e+06u l=150000u
X11 VPWR A Y VPB sky130_fd_pr__pfet_01v8_hvt w=1e+06u l=150000u
X12 VPWR A Y VPB sky130_fd_pr__pfet_01v8_hvt w=1e+06u l=150000u
X13 VPWR A Y VPB sky130_fd_pr__pfet_01v8_hvt w=1e+06u l=150000u
X14 VPWR A Y VPB sky130_fd_pr__pfet_01v8_hvt w=1e+06u l=150000u
X15 VPWR A Y VPB sky130_fd_pr__pfet_01v8_hvt w=1e+06u l=150000u
X16 Y A VPWR VPB sky130_fd_pr__pfet_01v8_hvt w=1e+06u l=150000u
X17 VGND A Y VNB sky130_fd_pr__nfet_01v8 w=420000u l=150000u
X18 Y A VGND VNB sky130_fd_pr__nfet_01v8 w=420000u l=150000u
X19 Y A VPWR VPB sky130_fd_pr__pfet_01v8_hvt w=1e+06u l=150000u
.ends
.subckt sky130_fd_sc_hd__conb_1 VGND VNB VPB VPWR HI LO
XR0 VGND LO sky130_fd_pr__res_generic_po w=480000u l=45000u
XR1 HI VPWR sky130_fd_pr__res_generic_po w=480000u l=45000u
.ends
.subckt sky130_fd_sc_hd__decap_3 VGND VNB VPB VPWR
X0 VPWR VGND VPWR VPB sky130_fd_pr__pfet_01v8_hvt w=870000u l=590000u
X1 VGND VPWR VGND VNB sky130_fd_pr__nfet_01v8 w=550000u l=590000u
.ends
.subckt sky130_fd_sc_hd__dfrtn_1 CLK_N D RESET_B VGND VNB VPB VPWR Q
X0 a_1270_413# a_1283_21# VPWR VPB sky130_fd_pr__pfet_01v8_hvt w=420000u l=150000u
X1 VPWR a_543_47# a_761_289# VPB sky130_fd_pr__pfet_01v8_hvt w=840000u l=150000u
X2 VGND a_543_47# a_761_289# VNB sky130_fd_pr__nfet_01v8 w=640000u l=150000u
X3 VGND D a_448_47# VNB sky130_fd_pr__nfet_01v8 w=420000u l=150000u
X4 a_1108_47# a_27_47# a_1270_413# VPB sky130_fd_pr__pfet_01v8_hvt w=420000u l=150000u
X5 VGND a_1283_21# Q VNB sky130_fd_pr__nfet_01v8 w=650000u l=150000u
X6 a_1217_47# a_1283_21# VGND VNB sky130_fd_pr__nfet_01v8 w=420000u l=150000u
X7 a_448_47# a_193_47# a_543_47# VNB sky130_fd_pr__special_nfet_01v8 w=360000u l=150000u
X8 a_448_47# a_27_47# a_543_47# VPB sky130_fd_pr__pfet_01v8_hvt w=420000u l=150000u
X9 a_543_47# a_27_47# a_639_47# VNB sky130_fd_pr__special_nfet_01v8 w=360000u l=150000u
X10 a_1108_47# a_193_47# a_1217_47# VNB sky130_fd_pr__special_nfet_01v8 w=360000u l=150000u
X11 a_1462_47# a_1108_47# a_1283_21# VNB sky130_fd_pr__nfet_01v8 w=420000u l=150000u
X12 a_543_47# a_193_47# a_651_413# VPB sky130_fd_pr__pfet_01v8_hvt w=420000u l=150000u
X13 a_805_47# RESET_B VGND VNB sky130_fd_pr__nfet_01v8 w=420000u l=150000u
X14 a_761_289# a_27_47# a_1108_47# VNB sky130_fd_pr__special_nfet_01v8 w=360000u l=150000u
X15 VPWR RESET_B a_651_413# VPB sky130_fd_pr__pfet_01v8_hvt w=420000u l=150000u
X16 VGND a_27_47# a_193_47# VNB sky130_fd_pr__nfet_01v8 w=420000u l=150000u
X17 a_27_47# CLK_N VGND VNB sky130_fd_pr__nfet_01v8 w=420000u l=150000u
X18 a_27_47# CLK_N VPWR VPB sky130_fd_pr__pfet_01v8_hvt w=640000u l=150000u
X19 VPWR a_1283_21# Q VPB sky130_fd_pr__pfet_01v8_hvt w=1e+06u l=150000u
X20 VPWR a_27_47# a_193_47# VPB sky130_fd_pr__pfet_01v8_hvt w=640000u l=150000u
X21 a_1283_21# a_1108_47# VPWR VPB sky130_fd_pr__pfet_01v8_hvt w=420000u l=150000u
X22 VGND RESET_B a_1462_47# VNB sky130_fd_pr__nfet_01v8 w=420000u l=150000u
X23 VPWR D a_448_47# VPB sky130_fd_pr__pfet_01v8_hvt w=420000u l=150000u
X24 a_651_413# a_761_289# VPWR VPB sky130_fd_pr__pfet_01v8_hvt w=420000u l=150000u
X25 a_761_289# a_193_47# a_1108_47# VPB sky130_fd_pr__pfet_01v8_hvt w=420000u l=150000u
X26 VPWR RESET_B a_1283_21# VPB sky130_fd_pr__pfet_01v8_hvt w=420000u l=150000u
X27 a_639_47# a_761_289# a_805_47# VNB sky130_fd_pr__nfet_01v8 w=420000u l=150000u
.ends
.subckt sky130_fd_sc_hd__dfrtp_1 CLK D RESET_B VGND VNB VPB VPWR Q
X0 a_1270_413# a_1283_21# VPWR VPB sky130_fd_pr__pfet_01v8_hvt w=420000u l=150000u
X1 VPWR a_543_47# a_761_289# VPB sky130_fd_pr__pfet_01v8_hvt w=840000u l=150000u
X2 VGND a_543_47# a_761_289# VNB sky130_fd_pr__nfet_01v8 w=640000u l=150000u
X3 VGND D a_448_47# VNB sky130_fd_pr__nfet_01v8 w=420000u l=150000u
X4 a_1108_47# a_193_47# a_1270_413# VPB sky130_fd_pr__pfet_01v8_hvt w=420000u l=150000u
X5 VGND a_1283_21# Q VNB sky130_fd_pr__nfet_01v8 w=650000u l=150000u
X6 a_1217_47# a_1283_21# VGND VNB sky130_fd_pr__nfet_01v8 w=420000u l=150000u
X7 a_448_47# a_27_47# a_543_47# VNB sky130_fd_pr__special_nfet_01v8 w=360000u l=150000u
X8 a_448_47# a_193_47# a_543_47# VPB sky130_fd_pr__pfet_01v8_hvt w=420000u l=150000u
X9 a_543_47# a_193_47# a_639_47# VNB sky130_fd_pr__special_nfet_01v8 w=360000u l=150000u
X10 a_1108_47# a_27_47# a_1217_47# VNB sky130_fd_pr__special_nfet_01v8 w=360000u l=150000u
X11 a_1462_47# a_1108_47# a_1283_21# VNB sky130_fd_pr__nfet_01v8 w=420000u l=150000u
X12 a_543_47# a_27_47# a_651_413# VPB sky130_fd_pr__pfet_01v8_hvt w=420000u l=150000u
X13 a_805_47# RESET_B VGND VNB sky130_fd_pr__nfet_01v8 w=420000u l=150000u
X14 a_761_289# a_193_47# a_1108_47# VNB sky130_fd_pr__special_nfet_01v8 w=360000u l=150000u
X15 VPWR RESET_B a_651_413# VPB sky130_fd_pr__pfet_01v8_hvt w=420000u l=150000u
X16 VGND a_27_47# a_193_47# VNB sky130_fd_pr__nfet_01v8 w=420000u l=150000u
X17 a_27_47# CLK VGND VNB sky130_fd_pr__nfet_01v8 w=420000u l=150000u
X18 a_27_47# CLK VPWR VPB sky130_fd_pr__pfet_01v8_hvt w=640000u l=150000u
X19 VPWR a_1283_21# Q VPB sky130_fd_pr__pfet_01v8_hvt w=1e+06u l=150000u
X20 VPWR a_27_47# a_193_47# VPB sky130_fd_pr__pfet_01v8_hvt w=640000u l=150000u
X21 a_1283_21# a_1108_47# VPWR VPB sky130_fd_pr__pfet_01v8_hvt w=420000u l=150000u
X22 VGND RESET_B a_1462_47# VNB sky130_fd_pr__nfet_01v8 w=420000u l=150000u
X23 VPWR D a_448_47# VPB sky130_fd_pr__pfet_01v8_hvt w=420000u l=150000u
X24 a_651_413# a_761_289# VPWR VPB sky130_fd_pr__pfet_01v8_hvt w=420000u l=150000u
X25 a_761_289# a_27_47# a_1108_47# VPB sky130_fd_pr__pfet_01v8_hvt w=420000u l=150000u
X26 VPWR RESET_B a_1283_21# VPB sky130_fd_pr__pfet_01v8_hvt w=420000u l=150000u
X27 a_639_47# a_761_289# a_805_47# VNB sky130_fd_pr__nfet_01v8 w=420000u l=150000u
.ends
.subckt sky130_fd_sc_hd__dfrtp_2 CLK D RESET_B VGND VNB VPB VPWR Q
X0 a_1270_413# a_1283_21# VPWR VPB sky130_fd_pr__pfet_01v8_hvt w=420000u l=150000u
X1 Q a_1283_21# VGND VNB sky130_fd_pr__nfet_01v8 w=650000u l=150000u
X2 VPWR a_543_47# a_761_289# VPB sky130_fd_pr__pfet_01v8_hvt w=840000u l=150000u
X3 VGND a_543_47# a_761_289# VNB sky130_fd_pr__nfet_01v8 w=640000u l=150000u
X4 VGND D a_448_47# VNB sky130_fd_pr__nfet_01v8 w=420000u l=150000u
X5 a_1108_47# a_193_47# a_1270_413# VPB sky130_fd_pr__pfet_01v8_hvt w=420000u l=150000u
X6 VGND a_1283_21# Q VNB sky130_fd_pr__nfet_01v8 w=650000u l=150000u
X7 a_1217_47# a_1283_21# VGND VNB sky130_fd_pr__nfet_01v8 w=420000u l=150000u
X8 a_448_47# a_27_47# a_543_47# VNB sky130_fd_pr__special_nfet_01v8 w=360000u l=150000u
X9 a_448_47# a_193_47# a_543_47# VPB sky130_fd_pr__pfet_01v8_hvt w=420000u l=150000u
X10 a_543_47# a_193_47# a_639_47# VNB sky130_fd_pr__special_nfet_01v8 w=360000u l=150000u
X11 a_1108_47# a_27_47# a_1217_47# VNB sky130_fd_pr__special_nfet_01v8 w=360000u l=150000u
X12 a_1462_47# a_1108_47# a_1283_21# VNB sky130_fd_pr__nfet_01v8 w=420000u l=150000u
X13 a_543_47# a_27_47# a_651_413# VPB sky130_fd_pr__pfet_01v8_hvt w=420000u l=150000u
X14 a_805_47# RESET_B VGND VNB sky130_fd_pr__nfet_01v8 w=420000u l=150000u
X15 Q a_1283_21# VPWR VPB sky130_fd_pr__pfet_01v8_hvt w=1e+06u l=150000u
X16 a_761_289# a_193_47# a_1108_47# VNB sky130_fd_pr__special_nfet_01v8 w=360000u l=150000u
X17 VPWR RESET_B a_651_413# VPB sky130_fd_pr__pfet_01v8_hvt w=420000u l=150000u
X18 VGND a_27_47# a_193_47# VNB sky130_fd_pr__nfet_01v8 w=420000u l=150000u
X19 a_27_47# CLK VGND VNB sky130_fd_pr__nfet_01v8 w=420000u l=150000u
X20 a_27_47# CLK VPWR VPB sky130_fd_pr__pfet_01v8_hvt w=640000u l=150000u
X21 VPWR a_1283_21# Q VPB sky130_fd_pr__pfet_01v8_hvt w=1e+06u l=150000u
X22 VPWR a_27_47# a_193_47# VPB sky130_fd_pr__pfet_01v8_hvt w=640000u l=150000u
X23 a_1283_21# a_1108_47# VPWR VPB sky130_fd_pr__pfet_01v8_hvt w=420000u l=150000u
X24 VGND RESET_B a_1462_47# VNB sky130_fd_pr__nfet_01v8 w=420000u l=150000u
X25 VPWR D a_448_47# VPB sky130_fd_pr__pfet_01v8_hvt w=420000u l=150000u
X26 a_651_413# a_761_289# VPWR VPB sky130_fd_pr__pfet_01v8_hvt w=420000u l=150000u
X27 a_761_289# a_27_47# a_1108_47# VPB sky130_fd_pr__pfet_01v8_hvt w=420000u l=150000u
X28 VPWR RESET_B a_1283_21# VPB sky130_fd_pr__pfet_01v8_hvt w=420000u l=150000u
X29 a_639_47# a_761_289# a_805_47# VNB sky130_fd_pr__nfet_01v8 w=420000u l=150000u
.ends
.subckt sky130_fd_sc_hd__dfrtp_4 CLK D RESET_B VGND VNB VPB VPWR Q
X0 a_1270_413# a_1283_21# VPWR VPB sky130_fd_pr__pfet_01v8_hvt w=420000u l=150000u
X1 VPWR a_543_47# a_761_289# VPB sky130_fd_pr__pfet_01v8_hvt w=840000u l=150000u
X2 VGND a_543_47# a_761_289# VNB sky130_fd_pr__nfet_01v8 w=640000u l=150000u
X3 VGND D a_448_47# VNB sky130_fd_pr__nfet_01v8 w=420000u l=150000u
X4 a_1108_47# a_193_47# a_1270_413# VPB sky130_fd_pr__pfet_01v8_hvt w=420000u l=150000u
X5 VPWR a_1283_21# Q VPB sky130_fd_pr__pfet_01v8_hvt w=1e+06u l=150000u
X6 a_1217_47# a_1283_21# VGND VNB sky130_fd_pr__nfet_01v8 w=420000u l=150000u
X7 a_448_47# a_27_47# a_543_47# VNB sky130_fd_pr__special_nfet_01v8 w=360000u l=150000u
X8 Q a_1283_21# VGND VNB sky130_fd_pr__nfet_01v8 w=650000u l=150000u
X9 a_448_47# a_193_47# a_543_47# VPB sky130_fd_pr__pfet_01v8_hvt w=420000u l=150000u
X10 a_543_47# a_193_47# a_639_47# VNB sky130_fd_pr__special_nfet_01v8 w=360000u l=150000u
X11 a_1108_47# a_27_47# a_1217_47# VNB sky130_fd_pr__special_nfet_01v8 w=360000u l=150000u
X12 a_1462_47# a_1108_47# a_1283_21# VNB sky130_fd_pr__nfet_01v8 w=420000u l=150000u
X13 VPWR a_1283_21# Q VPB sky130_fd_pr__pfet_01v8_hvt w=1e+06u l=150000u
X14 VGND a_1283_21# Q VNB sky130_fd_pr__nfet_01v8 w=650000u l=150000u
X15 a_543_47# a_27_47# a_651_413# VPB sky130_fd_pr__pfet_01v8_hvt w=420000u l=150000u
X16 a_805_47# RESET_B VGND VNB sky130_fd_pr__nfet_01v8 w=420000u l=150000u
X17 Q a_1283_21# VPWR VPB sky130_fd_pr__pfet_01v8_hvt w=1e+06u l=150000u
X18 Q a_1283_21# VPWR VPB sky130_fd_pr__pfet_01v8_hvt w=1e+06u l=150000u
X19 a_761_289# a_193_47# a_1108_47# VNB sky130_fd_pr__special_nfet_01v8 w=360000u l=150000u
X20 VPWR RESET_B a_651_413# VPB sky130_fd_pr__pfet_01v8_hvt w=420000u l=150000u
X21 VGND a_27_47# a_193_47# VNB sky130_fd_pr__nfet_01v8 w=420000u l=150000u
X22 a_27_47# CLK VGND VNB sky130_fd_pr__nfet_01v8 w=420000u l=150000u
X23 VGND a_1283_21# Q VNB sky130_fd_pr__nfet_01v8 w=650000u l=150000u
X24 a_27_47# CLK VPWR VPB sky130_fd_pr__pfet_01v8_hvt w=640000u l=150000u
X25 VPWR a_27_47# a_193_47# VPB sky130_fd_pr__pfet_01v8_hvt w=640000u l=150000u
X26 a_1283_21# a_1108_47# VPWR VPB sky130_fd_pr__pfet_01v8_hvt w=420000u l=150000u
X27 VGND RESET_B a_1462_47# VNB sky130_fd_pr__nfet_01v8 w=420000u l=150000u
X28 VPWR D a_448_47# VPB sky130_fd_pr__pfet_01v8_hvt w=420000u l=150000u
X29 Q a_1283_21# VGND VNB sky130_fd_pr__nfet_01v8 w=650000u l=150000u
X30 a_651_413# a_761_289# VPWR VPB sky130_fd_pr__pfet_01v8_hvt w=420000u l=150000u
X31 a_761_289# a_27_47# a_1108_47# VPB sky130_fd_pr__pfet_01v8_hvt w=420000u l=150000u
X32 VPWR RESET_B a_1283_21# VPB sky130_fd_pr__pfet_01v8_hvt w=420000u l=150000u
X33 a_639_47# a_761_289# a_805_47# VNB sky130_fd_pr__nfet_01v8 w=420000u l=150000u
.ends
.subckt sky130_fd_sc_hd__dfstp_1 CLK D SET_B VGND VNB VPB VPWR Q
X0 a_562_413# a_652_21# VPWR VPB sky130_fd_pr__pfet_01v8_hvt w=420000u l=150000u
X1 a_1296_47# SET_B VGND VNB sky130_fd_pr__nfet_01v8 w=420000u l=150000u
X2 a_381_47# a_193_47# a_476_47# VPB sky130_fd_pr__pfet_01v8_hvt w=420000u l=150000u
X3 a_1602_47# a_1032_413# VPWR VPB sky130_fd_pr__pfet_01v8_hvt w=640000u l=150000u
X4 a_1140_413# a_1182_261# VPWR VPB sky130_fd_pr__pfet_01v8_hvt w=420000u l=150000u
X5 a_1032_413# a_27_47# a_1224_47# VNB sky130_fd_pr__nfet_01v8 w=420000u l=150000u
X6 VGND a_1032_413# a_1182_261# VNB sky130_fd_pr__nfet_01v8 w=540000u l=150000u
X7 a_476_47# a_27_47# a_562_413# VPB sky130_fd_pr__pfet_01v8_hvt w=420000u l=150000u
X8 a_381_47# a_27_47# a_476_47# VNB sky130_fd_pr__special_nfet_01v8 w=360000u l=150000u
X9 VGND a_476_47# a_1056_47# VNB sky130_fd_pr__nfet_01v8 w=420000u l=150000u
X10 a_1602_47# a_1032_413# VGND VNB sky130_fd_pr__nfet_01v8 w=420000u l=150000u
X11 a_1056_47# a_193_47# a_1032_413# VNB sky130_fd_pr__nfet_01v8 w=420000u l=150000u
X12 VPWR SET_B a_652_21# VPB sky130_fd_pr__pfet_01v8_hvt w=420000u l=150000u
X13 a_796_47# a_476_47# a_652_21# VNB sky130_fd_pr__nfet_01v8 w=420000u l=150000u
X14 VPWR a_476_47# a_956_413# VPB sky130_fd_pr__pfet_01v8_hvt w=420000u l=150000u
X15 a_586_47# a_652_21# VGND VNB sky130_fd_pr__nfet_01v8 w=420000u l=150000u
X16 VPWR D a_381_47# VPB sky130_fd_pr__pfet_01v8_hvt w=840000u l=150000u
X17 a_652_21# a_476_47# VPWR VPB sky130_fd_pr__pfet_01v8_hvt w=420000u l=150000u
X18 a_1032_413# a_193_47# a_1140_413# VPB sky130_fd_pr__pfet_01v8_hvt w=420000u l=150000u
X19 VGND a_1602_47# Q VNB sky130_fd_pr__nfet_01v8 w=650000u l=150000u
X20 a_476_47# a_193_47# a_586_47# VNB sky130_fd_pr__special_nfet_01v8 w=360000u l=150000u
X21 a_1032_413# SET_B VPWR VPB sky130_fd_pr__pfet_01v8_hvt w=420000u l=150000u
X22 VGND a_27_47# a_193_47# VNB sky130_fd_pr__nfet_01v8 w=420000u l=150000u
X23 a_956_413# a_27_47# a_1032_413# VPB sky130_fd_pr__pfet_01v8_hvt w=420000u l=150000u
X24 a_27_47# CLK VGND VNB sky130_fd_pr__nfet_01v8 w=420000u l=150000u
X25 a_27_47# CLK VPWR VPB sky130_fd_pr__pfet_01v8_hvt w=640000u l=150000u
X26 VPWR a_1032_413# a_1182_261# VPB sky130_fd_pr__pfet_01v8_hvt w=840000u l=150000u
X27 a_1224_47# a_1182_261# a_1296_47# VNB sky130_fd_pr__nfet_01v8 w=420000u l=150000u
X28 VPWR a_27_47# a_193_47# VPB sky130_fd_pr__pfet_01v8_hvt w=640000u l=150000u
X29 VGND D a_381_47# VNB sky130_fd_pr__nfet_01v8 w=640000u l=150000u
X30 VGND SET_B a_796_47# VNB sky130_fd_pr__nfet_01v8 w=420000u l=150000u
X31 VPWR a_1602_47# Q VPB sky130_fd_pr__pfet_01v8_hvt w=1e+06u l=150000u
.ends
.subckt sky130_fd_sc_hd__dfxtp_1 CLK D VGND VNB VPB VPWR Q
X0 a_891_413# a_193_47# a_975_413# VPB sky130_fd_pr__pfet_01v8_hvt w=420000u l=150000u
X1 a_1059_315# a_891_413# VGND VNB sky130_fd_pr__nfet_01v8 w=650000u l=150000u
X2 a_466_413# a_27_47# a_561_413# VPB sky130_fd_pr__pfet_01v8_hvt w=420000u l=150000u
X3 a_634_159# a_27_47# a_891_413# VPB sky130_fd_pr__pfet_01v8_hvt w=420000u l=150000u
X4 a_381_47# a_193_47# a_466_413# VPB sky130_fd_pr__pfet_01v8_hvt w=420000u l=150000u
X5 VPWR D a_381_47# VPB sky130_fd_pr__pfet_01v8_hvt w=420000u l=150000u
X6 VPWR a_466_413# a_634_159# VPB sky130_fd_pr__pfet_01v8_hvt w=750000u l=150000u
X7 VGND a_466_413# a_634_159# VNB sky130_fd_pr__nfet_01v8 w=640000u l=150000u
X8 a_1017_47# a_1059_315# VGND VNB sky130_fd_pr__nfet_01v8 w=420000u l=150000u
X9 a_1059_315# a_891_413# VPWR VPB sky130_fd_pr__pfet_01v8_hvt w=1e+06u l=150000u
X10 a_561_413# a_634_159# VPWR VPB sky130_fd_pr__pfet_01v8_hvt w=420000u l=150000u
X11 VPWR a_1059_315# Q VPB sky130_fd_pr__pfet_01v8_hvt w=1e+06u l=150000u
X12 a_891_413# a_27_47# a_1017_47# VNB sky130_fd_pr__special_nfet_01v8 w=360000u l=150000u
X13 a_634_159# a_193_47# a_891_413# VNB sky130_fd_pr__special_nfet_01v8 w=360000u l=150000u
X14 a_592_47# a_634_159# VGND VNB sky130_fd_pr__nfet_01v8 w=420000u l=150000u
X15 a_466_413# a_193_47# a_592_47# VNB sky130_fd_pr__special_nfet_01v8 w=360000u l=150000u
X16 VGND a_27_47# a_193_47# VNB sky130_fd_pr__nfet_01v8 w=420000u l=150000u
X17 a_381_47# a_27_47# a_466_413# VNB sky130_fd_pr__special_nfet_01v8 w=360000u l=150000u
X18 a_27_47# CLK VGND VNB sky130_fd_pr__nfet_01v8 w=420000u l=150000u
X19 a_27_47# CLK VPWR VPB sky130_fd_pr__pfet_01v8_hvt w=640000u l=150000u
X20 VPWR a_27_47# a_193_47# VPB sky130_fd_pr__pfet_01v8_hvt w=640000u l=150000u
X21 VGND D a_381_47# VNB sky130_fd_pr__nfet_01v8 w=420000u l=150000u
X22 a_975_413# a_1059_315# VPWR VPB sky130_fd_pr__pfet_01v8_hvt w=420000u l=150000u
X23 VGND a_1059_315# Q VNB sky130_fd_pr__nfet_01v8 w=650000u l=150000u
.ends
.subckt sky130_fd_sc_hd__diode_2 DIODE VGND VNB VPB VPWR
XD0 VNB DIODE sky130_fd_pr__diode_pw2nd_05v5 perim=2.64e+06 area=4.347e+11
.ends
.subckt sky130_fd_sc_hd__dlclkp_1 CLK GATE VGND VNB VPB VPWR GCLK
X0 a_957_369# CLK VPWR VPB sky130_fd_pr__pfet_01v8_hvt w=640000u l=150000u
X1 VGND a_957_369# GCLK VNB sky130_fd_pr__nfet_01v8 w=650000u l=150000u
X2 a_642_307# a_476_413# VPWR VPB sky130_fd_pr__pfet_01v8_hvt w=1e+06u l=150000u
X3 a_476_413# a_27_47# a_600_413# VPB sky130_fd_pr__pfet_01v8_hvt w=420000u l=150000u
X4 a_600_413# a_642_307# VPWR VPB sky130_fd_pr__pfet_01v8_hvt w=420000u l=150000u
X5 VGND GATE a_396_119# VNB sky130_fd_pr__nfet_01v8 w=420000u l=150000u
X6 VPWR GATE a_381_369# VPB sky130_fd_pr__pfet_01v8_hvt w=640000u l=150000u
X7 a_476_413# a_193_47# a_651_47# VNB sky130_fd_pr__special_nfet_01v8 w=390000u l=150000u
X8 a_957_369# a_642_307# a_1042_47# VNB sky130_fd_pr__nfet_01v8 w=420000u l=150000u
X9 VPWR a_642_307# a_957_369# VPB sky130_fd_pr__pfet_01v8_hvt w=640000u l=150000u
X10 a_396_119# a_27_47# a_476_413# VNB sky130_fd_pr__nfet_01v8 w=420000u l=150000u
X11 a_1042_47# CLK VGND VNB sky130_fd_pr__nfet_01v8 w=420000u l=150000u
X12 VGND a_27_47# a_193_47# VNB sky130_fd_pr__nfet_01v8 w=420000u l=150000u
X13 a_27_47# CLK VGND VNB sky130_fd_pr__nfet_01v8 w=420000u l=150000u
X14 a_27_47# CLK VPWR VPB sky130_fd_pr__pfet_01v8_hvt w=640000u l=150000u
X15 a_651_47# a_642_307# VGND VNB sky130_fd_pr__nfet_01v8 w=420000u l=150000u
X16 VPWR a_27_47# a_193_47# VPB sky130_fd_pr__pfet_01v8_hvt w=640000u l=150000u
X17 VGND a_476_413# a_642_307# VNB sky130_fd_pr__nfet_01v8 w=650000u l=150000u
X18 VPWR a_957_369# GCLK VPB sky130_fd_pr__pfet_01v8_hvt w=1e+06u l=150000u
X19 a_381_369# a_193_47# a_476_413# VPB sky130_fd_pr__pfet_01v8_hvt w=420000u l=150000u
.ends
.subckt sky130_fd_sc_hd__dlygate4sd3_1 A VGND VNB VPB VPWR X
X0 a_391_47# a_285_47# VGND VNB sky130_fd_pr__nfet_01v8 w=420000u l=500000u
X1 VPWR a_49_47# a_285_47# VPB sky130_fd_pr__pfet_01v8_hvt w=420000u l=500000u
X2 a_49_47# A VGND VNB sky130_fd_pr__nfet_01v8 w=420000u l=150000u
X3 VPWR a_391_47# X VPB sky130_fd_pr__pfet_01v8_hvt w=1e+06u l=150000u
X4 VGND a_391_47# X VNB sky130_fd_pr__nfet_01v8 w=650000u l=150000u
X5 VGND a_49_47# a_285_47# VNB sky130_fd_pr__nfet_01v8 w=420000u l=500000u
X6 a_391_47# a_285_47# VPWR VPB sky130_fd_pr__pfet_01v8_hvt w=420000u l=500000u
X7 a_49_47# A VPWR VPB sky130_fd_pr__pfet_01v8_hvt w=420000u l=150000u
.ends
.subckt sky130_fd_sc_hd__fa_1 A B CIN VGND VNB VPB VPWR COUT SUM
X0 VGND A a_208_47# VNB sky130_fd_pr__nfet_01v8 w=420000u l=150000u
X1 VGND B a_382_47# VNB sky130_fd_pr__nfet_01v8 w=420000u l=150000u
X2 a_1163_413# A VPWR VPB sky130_fd_pr__pfet_01v8_hvt w=420000u l=150000u
X3 a_208_413# B a_76_199# VPB sky130_fd_pr__pfet_01v8_hvt w=420000u l=150000u
X4 a_382_413# A VPWR VPB sky130_fd_pr__pfet_01v8_hvt w=420000u l=150000u
X5 VPWR A a_738_413# VPB sky130_fd_pr__pfet_01v8_hvt w=420000u l=150000u
X6 a_76_199# CIN a_382_413# VPB sky130_fd_pr__pfet_01v8_hvt w=420000u l=150000u
X7 a_738_413# CIN VPWR VPB sky130_fd_pr__pfet_01v8_hvt w=420000u l=150000u
X8 a_995_47# CIN a_1091_413# VPB sky130_fd_pr__pfet_01v8_hvt w=420000u l=150000u
X9 VPWR B a_382_413# VPB sky130_fd_pr__pfet_01v8_hvt w=420000u l=150000u
X10 a_1091_413# B a_1163_413# VPB sky130_fd_pr__pfet_01v8_hvt w=420000u l=150000u
X11 VGND A a_738_47# VNB sky130_fd_pr__nfet_01v8 w=420000u l=150000u
X12 a_382_47# A VGND VNB sky130_fd_pr__nfet_01v8 w=420000u l=150000u
X13 VGND B a_738_47# VNB sky130_fd_pr__nfet_01v8 w=420000u l=150000u
X14 VPWR a_995_47# SUM VPB sky130_fd_pr__pfet_01v8_hvt w=1e+06u l=150000u
X15 a_738_47# CIN VGND VNB sky130_fd_pr__nfet_01v8 w=420000u l=150000u
X16 a_738_47# a_76_199# a_995_47# VNB sky130_fd_pr__nfet_01v8 w=420000u l=150000u
X17 a_76_199# CIN a_382_47# VNB sky130_fd_pr__nfet_01v8 w=420000u l=150000u
X18 a_1091_47# B a_1163_47# VNB sky130_fd_pr__nfet_01v8 w=420000u l=150000u
X19 a_738_413# a_76_199# a_995_47# VPB sky130_fd_pr__pfet_01v8_hvt w=420000u l=150000u
X20 VGND a_995_47# SUM VNB sky130_fd_pr__nfet_01v8 w=650000u l=150000u
X21 VPWR B a_738_413# VPB sky130_fd_pr__pfet_01v8_hvt w=420000u l=150000u
X22 a_1163_47# A VGND VNB sky130_fd_pr__nfet_01v8 w=420000u l=150000u
X23 VPWR A a_208_413# VPB sky130_fd_pr__pfet_01v8_hvt w=420000u l=150000u
X24 COUT a_76_199# VGND VNB sky130_fd_pr__nfet_01v8 w=650000u l=150000u
X25 COUT a_76_199# VPWR VPB sky130_fd_pr__pfet_01v8_hvt w=1e+06u l=150000u
X26 a_208_47# B a_76_199# VNB sky130_fd_pr__nfet_01v8 w=420000u l=150000u
X27 a_995_47# CIN a_1091_47# VNB sky130_fd_pr__nfet_01v8 w=420000u l=150000u
.ends
.subckt sky130_fd_sc_hd__fa_2 A B CIN VGND VNB VPB VPWR COUT SUM
X0 a_80_21# CIN a_473_371# VPB sky130_fd_pr__pfet_01v8_hvt w=630000u l=150000u
X1 a_289_371# B a_80_21# VPB sky130_fd_pr__pfet_01v8_hvt w=630000u l=150000u
X2 a_1086_47# CIN a_1171_369# VPB sky130_fd_pr__pfet_01v8_hvt w=640000u l=150000u
X3 a_829_47# CIN VGND VNB sky130_fd_pr__nfet_01v8 w=420000u l=150000u
X4 VPWR B a_473_371# VPB sky130_fd_pr__pfet_01v8_hvt w=630000u l=150000u
X5 VGND A a_294_47# VNB sky130_fd_pr__nfet_01v8 w=420000u l=150000u
X6 a_80_21# CIN a_473_47# VNB sky130_fd_pr__nfet_01v8 w=420000u l=150000u
X7 VPWR a_80_21# COUT VPB sky130_fd_pr__pfet_01v8_hvt w=1e+06u l=150000u
X8 VGND a_1086_47# SUM VNB sky130_fd_pr__nfet_01v8 w=650000u l=150000u
X9 VGND a_80_21# COUT VNB sky130_fd_pr__nfet_01v8 w=650000u l=150000u
X10 a_1266_47# A VGND VNB sky130_fd_pr__nfet_01v8 w=420000u l=150000u
X11 a_1194_47# B a_1266_47# VNB sky130_fd_pr__nfet_01v8 w=420000u l=150000u
X12 COUT a_80_21# VGND VNB sky130_fd_pr__nfet_01v8 w=650000u l=150000u
X13 VGND B a_829_47# VNB sky130_fd_pr__nfet_01v8 w=420000u l=150000u
X14 a_294_47# B a_80_21# VNB sky130_fd_pr__nfet_01v8 w=420000u l=150000u
X15 VPWR a_1086_47# SUM VPB sky130_fd_pr__pfet_01v8_hvt w=1e+06u l=150000u
X16 SUM a_1086_47# VGND VNB sky130_fd_pr__nfet_01v8 w=650000u l=150000u
X17 VGND B a_473_47# VNB sky130_fd_pr__nfet_01v8 w=420000u l=150000u
X18 VPWR A a_289_371# VPB sky130_fd_pr__pfet_01v8_hvt w=630000u l=150000u
X19 a_829_47# a_80_21# a_1086_47# VNB sky130_fd_pr__nfet_01v8 w=420000u l=150000u
X20 VPWR B a_829_369# VPB sky130_fd_pr__pfet_01v8_hvt w=640000u l=150000u
X21 SUM a_1086_47# VPWR VPB sky130_fd_pr__pfet_01v8_hvt w=1e+06u l=150000u
X22 VPWR A a_829_369# VPB sky130_fd_pr__pfet_01v8_hvt w=640000u l=150000u
X23 a_1086_47# CIN a_1194_47# VNB sky130_fd_pr__nfet_01v8 w=420000u l=150000u
X24 a_829_369# a_80_21# a_1086_47# VPB sky130_fd_pr__pfet_01v8_hvt w=640000u l=150000u
X25 a_1266_371# A VPWR VPB sky130_fd_pr__pfet_01v8_hvt w=630000u l=150000u
X26 a_829_369# CIN VPWR VPB sky130_fd_pr__pfet_01v8_hvt w=640000u l=150000u
X27 a_473_371# A VPWR VPB sky130_fd_pr__pfet_01v8_hvt w=630000u l=150000u
X28 a_1171_369# B a_1266_371# VPB sky130_fd_pr__pfet_01v8_hvt w=630000u l=150000u
X29 VGND A a_829_47# VNB sky130_fd_pr__nfet_01v8 w=420000u l=150000u
X30 COUT a_80_21# VPWR VPB sky130_fd_pr__pfet_01v8_hvt w=1e+06u l=150000u
X31 a_473_47# A VGND VNB sky130_fd_pr__nfet_01v8 w=420000u l=150000u
.ends
.subckt sky130_fd_sc_hd__fill_1 VGND VNB VPB VPWR
.ends
.subckt sky130_fd_sc_hd__fill_2 VGND VNB VPB VPWR
.ends
.subckt sky130_fd_sc_hd__inv_1 A VGND VNB VPB VPWR Y
X0 VGND A Y VNB sky130_fd_pr__nfet_01v8 w=650000u l=150000u
X1 VPWR A Y VPB sky130_fd_pr__pfet_01v8_hvt w=1e+06u l=150000u
.ends
.subckt sky130_fd_sc_hd__lpflow_inputiso1p_1 A SLEEP VGND VNB VPB VPWR X
X0 a_150_297# SLEEP VPWR VPB sky130_fd_pr__pfet_01v8_hvt w=420000u l=150000u
X1 VGND a_68_297# X VNB sky130_fd_pr__nfet_01v8 w=650000u l=150000u
X2 VGND A a_68_297# VNB sky130_fd_pr__nfet_01v8 w=420000u l=150000u
X3 a_68_297# SLEEP VGND VNB sky130_fd_pr__nfet_01v8 w=420000u l=150000u
X4 a_68_297# A a_150_297# VPB sky130_fd_pr__pfet_01v8_hvt w=420000u l=150000u
X5 VPWR a_68_297# X VPB sky130_fd_pr__pfet_01v8_hvt w=1e+06u l=150000u
.ends
.subckt sky130_fd_sc_hd__lpflow_isobufsrc_1 A SLEEP VGND VNB VPB VPWR X
X0 a_74_47# A VPWR VPB sky130_fd_pr__pfet_01v8_hvt w=420000u l=150000u
X1 X a_74_47# VGND VNB sky130_fd_pr__nfet_01v8 w=650000u l=150000u
X2 VGND SLEEP X VNB sky130_fd_pr__nfet_01v8 w=650000u l=150000u
X3 a_74_47# A VGND VNB sky130_fd_pr__nfet_01v8 w=420000u l=150000u
X4 VPWR SLEEP a_265_297# VPB sky130_fd_pr__pfet_01v8_hvt w=1e+06u l=150000u
X5 a_265_297# a_74_47# X VPB sky130_fd_pr__pfet_01v8_hvt w=1e+06u l=150000u
.ends
.subckt sky130_fd_sc_hd__maj3_1 A B C VGND VNB VPB VPWR X
X0 a_109_341# A VPWR VPB sky130_fd_pr__pfet_01v8_hvt w=420000u l=150000u
X1 a_265_47# B a_27_47# VNB sky130_fd_pr__nfet_01v8 w=420000u l=150000u
X2 a_27_47# B a_421_47# VNB sky130_fd_pr__nfet_01v8 w=420000u l=150000u
X3 VGND a_27_47# X VNB sky130_fd_pr__nfet_01v8 w=650000u l=150000u
X4 VGND A a_265_47# VNB sky130_fd_pr__nfet_01v8 w=420000u l=150000u
X5 a_109_47# A VGND VNB sky130_fd_pr__nfet_01v8 w=420000u l=150000u
X6 a_27_47# B a_421_341# VPB sky130_fd_pr__pfet_01v8_hvt w=420000u l=150000u
X7 a_421_341# C VPWR VPB sky130_fd_pr__pfet_01v8_hvt w=420000u l=150000u
X8 VPWR a_27_47# X VPB sky130_fd_pr__pfet_01v8_hvt w=1e+06u l=150000u
X9 a_421_47# C VGND VNB sky130_fd_pr__nfet_01v8 w=420000u l=150000u
X10 a_27_47# C a_109_47# VNB sky130_fd_pr__nfet_01v8 w=420000u l=150000u
X11 a_27_47# C a_109_341# VPB sky130_fd_pr__pfet_01v8_hvt w=420000u l=150000u
X12 VPWR A a_265_341# VPB sky130_fd_pr__pfet_01v8_hvt w=420000u l=150000u
X13 a_265_341# B a_27_47# VPB sky130_fd_pr__pfet_01v8_hvt w=420000u l=150000u
.ends
.subckt sky130_fd_sc_hd__mux2_1 A0 A1 S VGND VNB VPB VPWR X
X0 VPWR S a_218_374# VPB sky130_fd_pr__pfet_01v8_hvt w=420000u l=150000u
X1 a_76_199# A0 a_439_47# VNB sky130_fd_pr__nfet_01v8 w=420000u l=150000u
X2 a_535_374# a_505_21# VPWR VPB sky130_fd_pr__pfet_01v8_hvt w=420000u l=150000u
X3 VPWR S a_505_21# VPB sky130_fd_pr__pfet_01v8_hvt w=420000u l=150000u
X4 a_76_199# A1 a_535_374# VPB sky130_fd_pr__pfet_01v8_hvt w=420000u l=150000u
X5 a_218_47# A1 a_76_199# VNB sky130_fd_pr__nfet_01v8 w=420000u l=150000u
X6 a_218_374# A0 a_76_199# VPB sky130_fd_pr__pfet_01v8_hvt w=420000u l=150000u
X7 X a_76_199# VGND VNB sky130_fd_pr__nfet_01v8 w=650000u l=150000u
X8 X a_76_199# VPWR VPB sky130_fd_pr__pfet_01v8_hvt w=1e+06u l=150000u
X9 VGND S a_218_47# VNB sky130_fd_pr__nfet_01v8 w=420000u l=150000u
X10 VGND S a_505_21# VNB sky130_fd_pr__nfet_01v8 w=420000u l=150000u
X11 a_439_47# a_505_21# VGND VNB sky130_fd_pr__nfet_01v8 w=420000u l=150000u
.ends
.subckt sky130_fd_sc_hd__mux2i_1 A0 A1 S VGND VNB VPB VPWR Y
X0 a_283_205# S VPWR VPB sky130_fd_pr__pfet_01v8_hvt w=1e+06u l=150000u
X1 VPWR S a_27_297# VPB sky130_fd_pr__pfet_01v8_hvt w=1e+06u l=150000u
X2 a_27_297# A0 Y VPB sky130_fd_pr__pfet_01v8_hvt w=1e+06u l=150000u
X3 VGND S a_193_47# VNB sky130_fd_pr__nfet_01v8 w=650000u l=150000u
X4 a_204_297# a_283_205# VPWR VPB sky130_fd_pr__pfet_01v8_hvt w=1e+06u l=150000u
X5 a_27_47# a_283_205# VGND VNB sky130_fd_pr__nfet_01v8 w=650000u l=150000u
X6 a_283_205# S VGND VNB sky130_fd_pr__nfet_01v8 w=650000u l=150000u
X7 Y A1 a_204_297# VPB sky130_fd_pr__pfet_01v8_hvt w=1e+06u l=150000u
X8 Y A1 a_193_47# VNB sky130_fd_pr__nfet_01v8 w=650000u l=150000u
X9 a_27_47# A0 Y VNB sky130_fd_pr__nfet_01v8 w=650000u l=150000u
.ends
.subckt sky130_fd_sc_hd__mux2i_2 A0 A1 S VGND VNB VPB VPWR Y
X0 a_361_47# a_27_47# VGND VNB sky130_fd_pr__nfet_01v8 w=650000u l=150000u
X1 a_193_47# A1 Y VNB sky130_fd_pr__nfet_01v8 w=650000u l=150000u
X2 Y A0 a_361_47# VNB sky130_fd_pr__nfet_01v8 w=650000u l=150000u
X3 VGND a_27_47# a_361_47# VNB sky130_fd_pr__nfet_01v8 w=650000u l=150000u
X4 Y A1 a_361_297# VPB sky130_fd_pr__pfet_01v8_hvt w=1e+06u l=150000u
X5 Y A0 a_193_297# VPB sky130_fd_pr__pfet_01v8_hvt w=1e+06u l=150000u
X6 a_361_47# A0 Y VNB sky130_fd_pr__nfet_01v8 w=650000u l=150000u
X7 a_361_297# A1 Y VPB sky130_fd_pr__pfet_01v8_hvt w=1e+06u l=150000u
X8 a_193_47# S VGND VNB sky130_fd_pr__nfet_01v8 w=650000u l=150000u
X9 VGND S a_193_47# VNB sky130_fd_pr__nfet_01v8 w=650000u l=150000u
X10 a_193_297# S VPWR VPB sky130_fd_pr__pfet_01v8_hvt w=1e+06u l=150000u
X11 a_193_297# A0 Y VPB sky130_fd_pr__pfet_01v8_hvt w=1e+06u l=150000u
X12 a_27_47# S VGND VNB sky130_fd_pr__nfet_01v8 w=650000u l=150000u
X13 Y A1 a_193_47# VNB sky130_fd_pr__nfet_01v8 w=650000u l=150000u
X14 a_361_297# a_27_47# VPWR VPB sky130_fd_pr__pfet_01v8_hvt w=1e+06u l=150000u
X15 a_27_47# S VPWR VPB sky130_fd_pr__pfet_01v8_hvt w=1e+06u l=150000u
X16 VPWR S a_193_297# VPB sky130_fd_pr__pfet_01v8_hvt w=1e+06u l=150000u
X17 VPWR a_27_47# a_361_297# VPB sky130_fd_pr__pfet_01v8_hvt w=1e+06u l=150000u
.ends
.subckt sky130_fd_sc_hd__mux4_1 A0 A1 A2 A3 S0 S1 VGND VNB VPB VPWR X
X0 a_277_47# S1 a_1478_413# VPB sky130_fd_pr__pfet_01v8_hvt w=420000u l=150000u
X1 a_757_363# S0 a_750_97# VPB sky130_fd_pr__pfet_01v8_hvt w=420000u l=150000u
X2 a_668_97# S0 a_750_97# VNB sky130_fd_pr__nfet_01v8 w=420000u l=150000u
X3 a_750_97# S1 a_1478_413# VNB sky130_fd_pr__nfet_01v8 w=420000u l=150000u
X4 VPWR A2 a_757_363# VPB sky130_fd_pr__pfet_01v8_hvt w=420000u l=150000u
X5 a_277_47# S0 a_27_47# VNB sky130_fd_pr__nfet_01v8 w=420000u l=150000u
X6 a_1478_413# a_1290_413# a_277_47# VNB sky130_fd_pr__nfet_01v8 w=420000u l=150000u
X7 a_277_47# S0 a_193_413# VPB sky130_fd_pr__pfet_01v8_hvt w=420000u l=150000u
X8 a_923_363# A3 VPWR VPB sky130_fd_pr__pfet_01v8_hvt w=420000u l=150000u
X9 VPWR a_1478_413# X VPB sky130_fd_pr__pfet_01v8_hvt w=1e+06u l=150000u
X10 a_27_413# a_247_21# a_277_47# VPB sky130_fd_pr__pfet_01v8_hvt w=420000u l=150000u
X11 a_668_97# A3 VGND VNB sky130_fd_pr__nfet_01v8 w=420000u l=150000u
X12 VGND a_1478_413# X VNB sky130_fd_pr__nfet_01v8 w=650000u l=150000u
X13 a_193_47# a_247_21# a_277_47# VNB sky130_fd_pr__nfet_01v8 w=420000u l=150000u
X14 a_247_21# S0 VGND VNB sky130_fd_pr__nfet_01v8 w=420000u l=150000u
X15 a_27_413# A1 VPWR VPB sky130_fd_pr__pfet_01v8_hvt w=420000u l=150000u
X16 VPWR A0 a_193_413# VPB sky130_fd_pr__pfet_01v8_hvt w=420000u l=150000u
X17 a_1478_413# a_1290_413# a_750_97# VPB sky130_fd_pr__pfet_01v8_hvt w=420000u l=150000u
X18 a_247_21# S0 VPWR VPB sky130_fd_pr__pfet_01v8_hvt w=420000u l=150000u
X19 a_750_97# a_247_21# a_923_363# VPB sky130_fd_pr__pfet_01v8_hvt w=420000u l=150000u
X20 VPWR S1 a_1290_413# VPB sky130_fd_pr__pfet_01v8_hvt w=420000u l=150000u
X21 VGND A0 a_193_47# VNB sky130_fd_pr__nfet_01v8 w=420000u l=150000u
X22 a_27_47# A1 VGND VNB sky130_fd_pr__nfet_01v8 w=420000u l=150000u
X23 VGND A2 a_834_97# VNB sky130_fd_pr__nfet_01v8 w=420000u l=150000u
X24 a_750_97# a_247_21# a_834_97# VNB sky130_fd_pr__nfet_01v8 w=420000u l=150000u
X25 VGND S1 a_1290_413# VNB sky130_fd_pr__nfet_01v8 w=420000u l=150000u
.ends
.subckt sky130_fd_sc_hd__nand2_1 A B VGND VNB VPB VPWR Y
X0 Y A VPWR VPB sky130_fd_pr__pfet_01v8_hvt w=1e+06u l=150000u
X1 VPWR B Y VPB sky130_fd_pr__pfet_01v8_hvt w=1e+06u l=150000u
X2 VGND B a_113_47# VNB sky130_fd_pr__nfet_01v8 w=650000u l=150000u
X3 a_113_47# A Y VNB sky130_fd_pr__nfet_01v8 w=650000u l=150000u
.ends
.subckt sky130_fd_sc_hd__nand2b_1 A_N B VGND VNB VPB VPWR Y
X0 a_206_47# a_27_93# Y VNB sky130_fd_pr__nfet_01v8 w=650000u l=150000u
X1 a_27_93# A_N VGND VNB sky130_fd_pr__nfet_01v8 w=420000u l=150000u
X2 VGND B a_206_47# VNB sky130_fd_pr__nfet_01v8 w=650000u l=150000u
X3 VPWR B Y VPB sky130_fd_pr__pfet_01v8_hvt w=1e+06u l=150000u
X4 a_27_93# A_N VPWR VPB sky130_fd_pr__pfet_01v8_hvt w=420000u l=150000u
X5 Y a_27_93# VPWR VPB sky130_fd_pr__pfet_01v8_hvt w=1e+06u l=150000u
.ends
.subckt sky130_fd_sc_hd__nand3_1 A B C VGND VNB VPB VPWR Y
X0 VPWR A Y VPB sky130_fd_pr__pfet_01v8_hvt w=1e+06u l=150000u
X1 a_109_47# B a_193_47# VNB sky130_fd_pr__nfet_01v8 w=650000u l=150000u
X2 VGND C a_109_47# VNB sky130_fd_pr__nfet_01v8 w=650000u l=150000u
X3 a_193_47# A Y VNB sky130_fd_pr__nfet_01v8 w=650000u l=150000u
X4 VPWR C Y VPB sky130_fd_pr__pfet_01v8_hvt w=1e+06u l=150000u
X5 Y B VPWR VPB sky130_fd_pr__pfet_01v8_hvt w=1e+06u l=150000u
.ends
.subckt sky130_fd_sc_hd__nand4_2 A B C D VGND VNB VPB VPWR Y
X0 VPWR B Y VPB sky130_fd_pr__pfet_01v8_hvt w=1e+06u l=150000u
X1 a_277_47# C a_27_47# VNB sky130_fd_pr__nfet_01v8 w=650000u l=150000u
X2 Y A VPWR VPB sky130_fd_pr__pfet_01v8_hvt w=1e+06u l=150000u
X3 Y B VPWR VPB sky130_fd_pr__pfet_01v8_hvt w=1e+06u l=150000u
X4 VPWR A Y VPB sky130_fd_pr__pfet_01v8_hvt w=1e+06u l=150000u
X5 a_27_47# C a_277_47# VNB sky130_fd_pr__nfet_01v8 w=650000u l=150000u
X6 a_277_47# B a_471_47# VNB sky130_fd_pr__nfet_01v8 w=650000u l=150000u
X7 VGND D a_27_47# VNB sky130_fd_pr__nfet_01v8 w=650000u l=150000u
X8 VPWR C Y VPB sky130_fd_pr__pfet_01v8_hvt w=1e+06u l=150000u
X9 a_27_47# D VGND VNB sky130_fd_pr__nfet_01v8 w=650000u l=150000u
X10 Y A a_471_47# VNB sky130_fd_pr__nfet_01v8 w=650000u l=150000u
X11 VPWR D Y VPB sky130_fd_pr__pfet_01v8_hvt w=1e+06u l=150000u
X12 Y D VPWR VPB sky130_fd_pr__pfet_01v8_hvt w=1e+06u l=150000u
X13 a_471_47# A Y VNB sky130_fd_pr__nfet_01v8 w=650000u l=150000u
X14 Y C VPWR VPB sky130_fd_pr__pfet_01v8_hvt w=1e+06u l=150000u
X15 a_471_47# B a_277_47# VNB sky130_fd_pr__nfet_01v8 w=650000u l=150000u
.ends
.subckt sky130_fd_sc_hd__nand4_4 A B C D VGND VNB VPB VPWR Y
X0 VPWR A Y VPB sky130_fd_pr__pfet_01v8_hvt w=1e+06u l=150000u
X1 a_803_47# B a_445_47# VNB sky130_fd_pr__nfet_01v8 w=650000u l=150000u
X2 a_27_47# C a_445_47# VNB sky130_fd_pr__nfet_01v8 w=650000u l=150000u
X3 a_27_47# C a_445_47# VNB sky130_fd_pr__nfet_01v8 w=650000u l=150000u
X4 a_803_47# B a_445_47# VNB sky130_fd_pr__nfet_01v8 w=650000u l=150000u
X5 Y A a_803_47# VNB sky130_fd_pr__nfet_01v8 w=650000u l=150000u
X6 Y C VPWR VPB sky130_fd_pr__pfet_01v8_hvt w=1e+06u l=150000u
X7 Y C VPWR VPB sky130_fd_pr__pfet_01v8_hvt w=1e+06u l=150000u
X8 VGND D a_27_47# VNB sky130_fd_pr__nfet_01v8 w=650000u l=150000u
X9 VPWR C Y VPB sky130_fd_pr__pfet_01v8_hvt w=1e+06u l=150000u
X10 a_445_47# C a_27_47# VNB sky130_fd_pr__nfet_01v8 w=650000u l=150000u
X11 Y B VPWR VPB sky130_fd_pr__pfet_01v8_hvt w=1e+06u l=150000u
X12 VPWR A Y VPB sky130_fd_pr__pfet_01v8_hvt w=1e+06u l=150000u
X13 VPWR B Y VPB sky130_fd_pr__pfet_01v8_hvt w=1e+06u l=150000u
X14 a_27_47# D VGND VNB sky130_fd_pr__nfet_01v8 w=650000u l=150000u
X15 Y A a_803_47# VNB sky130_fd_pr__nfet_01v8 w=650000u l=150000u
X16 Y B VPWR VPB sky130_fd_pr__pfet_01v8_hvt w=1e+06u l=150000u
X17 VGND D a_27_47# VNB sky130_fd_pr__nfet_01v8 w=650000u l=150000u
X18 VPWR D Y VPB sky130_fd_pr__pfet_01v8_hvt w=1e+06u l=150000u
X19 a_27_47# D VGND VNB sky130_fd_pr__nfet_01v8 w=650000u l=150000u
X20 a_803_47# A Y VNB sky130_fd_pr__nfet_01v8 w=650000u l=150000u
X21 VPWR B Y VPB sky130_fd_pr__pfet_01v8_hvt w=1e+06u l=150000u
X22 VPWR C Y VPB sky130_fd_pr__pfet_01v8_hvt w=1e+06u l=150000u
X23 Y A VPWR VPB sky130_fd_pr__pfet_01v8_hvt w=1e+06u l=150000u
X24 a_803_47# A Y VNB sky130_fd_pr__nfet_01v8 w=650000u l=150000u
X25 VPWR D Y VPB sky130_fd_pr__pfet_01v8_hvt w=1e+06u l=150000u
X26 Y D VPWR VPB sky130_fd_pr__pfet_01v8_hvt w=1e+06u l=150000u
X27 Y A VPWR VPB sky130_fd_pr__pfet_01v8_hvt w=1e+06u l=150000u
X28 a_445_47# B a_803_47# VNB sky130_fd_pr__nfet_01v8 w=650000u l=150000u
X29 a_445_47# C a_27_47# VNB sky130_fd_pr__nfet_01v8 w=650000u l=150000u
X30 Y D VPWR VPB sky130_fd_pr__pfet_01v8_hvt w=1e+06u l=150000u
X31 a_445_47# B a_803_47# VNB sky130_fd_pr__nfet_01v8 w=650000u l=150000u
.ends
.subckt sky130_fd_sc_hd__nand4b_1 A_N B C D VGND VNB VPB VPWR Y
X0 Y a_41_93# VPWR VPB sky130_fd_pr__pfet_01v8_hvt w=1e+06u l=150000u
X1 a_232_47# C a_316_47# VNB sky130_fd_pr__nfet_01v8 w=650000u l=150000u
X2 a_423_47# a_41_93# Y VNB sky130_fd_pr__nfet_01v8 w=650000u l=150000u
X3 a_41_93# A_N VPWR VPB sky130_fd_pr__pfet_01v8_hvt w=420000u l=150000u
X4 VPWR D Y VPB sky130_fd_pr__pfet_01v8_hvt w=1e+06u l=150000u
X5 a_316_47# B a_423_47# VNB sky130_fd_pr__nfet_01v8 w=650000u l=150000u
X6 a_41_93# A_N VGND VNB sky130_fd_pr__nfet_01v8 w=420000u l=150000u
X7 VPWR B Y VPB sky130_fd_pr__pfet_01v8_hvt w=1e+06u l=150000u
X8 Y C VPWR VPB sky130_fd_pr__pfet_01v8_hvt w=1e+06u l=150000u
X9 VGND D a_232_47# VNB sky130_fd_pr__nfet_01v8 w=650000u l=150000u
.ends
.subckt sky130_fd_sc_hd__nor2_1 A B VGND VNB VPB VPWR Y
X0 a_109_297# A VPWR VPB sky130_fd_pr__pfet_01v8_hvt w=1e+06u l=150000u
X1 Y A VGND VNB sky130_fd_pr__nfet_01v8 w=650000u l=150000u
X2 VGND B Y VNB sky130_fd_pr__nfet_01v8 w=650000u l=150000u
X3 Y B a_109_297# VPB sky130_fd_pr__pfet_01v8_hvt w=1e+06u l=150000u
.ends
.subckt sky130_fd_sc_hd__nor2_2 A B VGND VNB VPB VPWR Y
X0 Y B VGND VNB sky130_fd_pr__nfet_01v8 w=650000u l=150000u
X1 VPWR A a_27_297# VPB sky130_fd_pr__pfet_01v8_hvt w=1e+06u l=150000u
X2 Y B a_27_297# VPB sky130_fd_pr__pfet_01v8_hvt w=1e+06u l=150000u
X3 VGND B Y VNB sky130_fd_pr__nfet_01v8 w=650000u l=150000u
X4 a_27_297# B Y VPB sky130_fd_pr__pfet_01v8_hvt w=1e+06u l=150000u
X5 a_27_297# A VPWR VPB sky130_fd_pr__pfet_01v8_hvt w=1e+06u l=150000u
X6 VGND A Y VNB sky130_fd_pr__nfet_01v8 w=650000u l=150000u
X7 Y A VGND VNB sky130_fd_pr__nfet_01v8 w=650000u l=150000u
.ends
.subckt sky130_fd_sc_hd__nor3_1 A B C VGND VNB VPB VPWR Y
X0 Y A VGND VNB sky130_fd_pr__nfet_01v8 w=650000u l=150000u
X1 VGND B Y VNB sky130_fd_pr__nfet_01v8 w=650000u l=150000u
X2 a_193_297# A VPWR VPB sky130_fd_pr__pfet_01v8_hvt w=1e+06u l=150000u
X3 Y C VGND VNB sky130_fd_pr__nfet_01v8 w=650000u l=150000u
X4 Y C a_109_297# VPB sky130_fd_pr__pfet_01v8_hvt w=1e+06u l=150000u
X5 a_109_297# B a_193_297# VPB sky130_fd_pr__pfet_01v8_hvt w=1e+06u l=150000u
.ends
.subckt sky130_fd_sc_hd__nor3b_1 A B C_N VGND VNB VPB VPWR Y
X0 Y A VGND VNB sky130_fd_pr__nfet_01v8 w=650000u l=150000u
X1 VPWR C_N a_91_199# VPB sky130_fd_pr__pfet_01v8_hvt w=420000u l=150000u
X2 a_161_297# B a_245_297# VPB sky130_fd_pr__pfet_01v8_hvt w=1e+06u l=150000u
X3 VGND C_N a_91_199# VNB sky130_fd_pr__nfet_01v8 w=420000u l=150000u
X4 Y a_91_199# a_161_297# VPB sky130_fd_pr__pfet_01v8_hvt w=1e+06u l=150000u
X5 a_245_297# A VPWR VPB sky130_fd_pr__pfet_01v8_hvt w=1e+06u l=150000u
X6 VGND B Y VNB sky130_fd_pr__nfet_01v8 w=650000u l=150000u
X7 Y a_91_199# VGND VNB sky130_fd_pr__nfet_01v8 w=650000u l=150000u
.ends
.subckt sky130_fd_sc_hd__nor4b_2 A B C D_N VGND VNB VPB VPWR Y
X0 a_277_297# C a_474_297# VPB sky130_fd_pr__pfet_01v8_hvt w=1e+06u l=150000u
X1 Y a_694_21# VGND VNB sky130_fd_pr__nfet_01v8 w=650000u l=150000u
X2 Y B VGND VNB sky130_fd_pr__nfet_01v8 w=650000u l=150000u
X3 VGND a_694_21# Y VNB sky130_fd_pr__nfet_01v8 w=650000u l=150000u
X4 Y a_694_21# a_474_297# VPB sky130_fd_pr__pfet_01v8_hvt w=1e+06u l=150000u
X5 VGND C Y VNB sky130_fd_pr__nfet_01v8 w=650000u l=150000u
X6 a_474_297# a_694_21# Y VPB sky130_fd_pr__pfet_01v8_hvt w=1e+06u l=150000u
X7 VGND B Y VNB sky130_fd_pr__nfet_01v8 w=650000u l=150000u
X8 a_694_21# D_N VPWR VPB sky130_fd_pr__pfet_01v8_hvt w=420000u l=150000u
X9 Y A VGND VNB sky130_fd_pr__nfet_01v8 w=650000u l=150000u
X10 a_27_297# B a_277_297# VPB sky130_fd_pr__pfet_01v8_hvt w=1e+06u l=150000u
X11 VGND A Y VNB sky130_fd_pr__nfet_01v8 w=650000u l=150000u
X12 a_27_297# A VPWR VPB sky130_fd_pr__pfet_01v8_hvt w=1e+06u l=150000u
X13 a_474_297# C a_277_297# VPB sky130_fd_pr__pfet_01v8_hvt w=1e+06u l=150000u
X14 VPWR A a_27_297# VPB sky130_fd_pr__pfet_01v8_hvt w=1e+06u l=150000u
X15 Y C VGND VNB sky130_fd_pr__nfet_01v8 w=650000u l=150000u
X16 a_277_297# B a_27_297# VPB sky130_fd_pr__pfet_01v8_hvt w=1e+06u l=150000u
X17 a_694_21# D_N VGND VNB sky130_fd_pr__nfet_01v8 w=420000u l=150000u
.ends
.subckt sky130_fd_sc_hd__o211ai_1 A1 A2 B1 C1 VGND VNB VPB VPWR Y
X0 a_110_297# A2 Y VPB sky130_fd_pr__pfet_01v8_hvt w=1e+06u l=150000u
X1 VPWR A1 a_110_297# VPB sky130_fd_pr__pfet_01v8_hvt w=1e+06u l=150000u
X2 a_27_47# A1 VGND VNB sky130_fd_pr__nfet_01v8 w=650000u l=150000u
X3 a_326_47# C1 Y VNB sky130_fd_pr__nfet_01v8 w=650000u l=150000u
X4 VPWR C1 Y VPB sky130_fd_pr__pfet_01v8_hvt w=1e+06u l=150000u
X5 VGND A2 a_27_47# VNB sky130_fd_pr__nfet_01v8 w=650000u l=150000u
X6 a_27_47# B1 a_326_47# VNB sky130_fd_pr__nfet_01v8 w=650000u l=150000u
X7 Y B1 VPWR VPB sky130_fd_pr__pfet_01v8_hvt w=1e+06u l=150000u
.ends
.subckt sky130_fd_sc_hd__o21a_1 A1 A2 B1 VGND VNB VPB VPWR X
X0 a_382_297# A1 VPWR VPB sky130_fd_pr__pfet_01v8_hvt w=1e+06u l=150000u
X1 VGND A1 a_297_47# VNB sky130_fd_pr__nfet_01v8 w=650000u l=150000u
X2 a_79_21# B1 a_297_47# VNB sky130_fd_pr__nfet_01v8 w=650000u l=150000u
X3 X a_79_21# VPWR VPB sky130_fd_pr__pfet_01v8_hvt w=1e+06u l=150000u
X4 a_297_47# A2 VGND VNB sky130_fd_pr__nfet_01v8 w=650000u l=150000u
X5 a_79_21# A2 a_382_297# VPB sky130_fd_pr__pfet_01v8_hvt w=1e+06u l=150000u
X6 VPWR B1 a_79_21# VPB sky130_fd_pr__pfet_01v8_hvt w=1e+06u l=150000u
X7 X a_79_21# VGND VNB sky130_fd_pr__nfet_01v8 w=650000u l=150000u
.ends
.subckt sky130_fd_sc_hd__o21ai_0 A1 A2 B1 VGND VNB VPB VPWR Y
X0 VGND A2 a_32_47# VNB sky130_fd_pr__nfet_01v8 w=420000u l=150000u
X1 Y B1 VPWR VPB sky130_fd_pr__pfet_01v8_hvt w=640000u l=150000u
X2 a_32_47# B1 Y VNB sky130_fd_pr__nfet_01v8 w=420000u l=150000u
X3 a_32_47# A1 VGND VNB sky130_fd_pr__nfet_01v8 w=420000u l=150000u
X4 VPWR A1 a_120_369# VPB sky130_fd_pr__pfet_01v8_hvt w=640000u l=150000u
X5 a_120_369# A2 Y VPB sky130_fd_pr__pfet_01v8_hvt w=640000u l=150000u
.ends
.subckt sky130_fd_sc_hd__o21ai_1 A1 A2 B1 VGND VNB VPB VPWR Y
X0 a_109_297# A2 Y VPB sky130_fd_pr__pfet_01v8_hvt w=1e+06u l=150000u
X1 Y B1 VPWR VPB sky130_fd_pr__pfet_01v8_hvt w=700000u l=150000u
X2 a_27_47# A1 VGND VNB sky130_fd_pr__nfet_01v8 w=650000u l=150000u
X3 a_27_47# B1 Y VNB sky130_fd_pr__nfet_01v8 w=650000u l=150000u
X4 VPWR A1 a_109_297# VPB sky130_fd_pr__pfet_01v8_hvt w=1e+06u l=150000u
X5 VGND A2 a_27_47# VNB sky130_fd_pr__nfet_01v8 w=650000u l=150000u
.ends
.subckt sky130_fd_sc_hd__o21ai_2 A1 A2 B1 VGND VNB VPB VPWR Y
X0 a_112_297# A2 Y VPB sky130_fd_pr__pfet_01v8_hvt w=1e+06u l=150000u
X1 VGND A2 a_29_47# VNB sky130_fd_pr__nfet_01v8 w=650000u l=150000u
X2 VPWR B1 Y VPB sky130_fd_pr__pfet_01v8_hvt w=1e+06u l=150000u
X3 VPWR A1 a_112_297# VPB sky130_fd_pr__pfet_01v8_hvt w=1e+06u l=150000u
X4 a_29_47# A2 VGND VNB sky130_fd_pr__nfet_01v8 w=650000u l=150000u
X5 VGND A1 a_29_47# VNB sky130_fd_pr__nfet_01v8 w=650000u l=150000u
X6 Y A2 a_112_297# VPB sky130_fd_pr__pfet_01v8_hvt w=1e+06u l=150000u
X7 Y B1 VPWR VPB sky130_fd_pr__pfet_01v8_hvt w=1e+06u l=150000u
X8 a_112_297# A1 VPWR VPB sky130_fd_pr__pfet_01v8_hvt w=1e+06u l=150000u
X9 a_29_47# B1 Y VNB sky130_fd_pr__nfet_01v8 w=650000u l=150000u
X10 a_29_47# A1 VGND VNB sky130_fd_pr__nfet_01v8 w=650000u l=150000u
X11 Y B1 a_29_47# VNB sky130_fd_pr__nfet_01v8 w=650000u l=150000u
.ends
.subckt sky130_fd_sc_hd__o21bai_1 A1 A2 B1_N VGND VNB VPB VPWR Y
X0 VGND A1 a_297_47# VNB sky130_fd_pr__nfet_01v8 w=650000u l=150000u
X1 Y a_105_352# a_297_47# VNB sky130_fd_pr__nfet_01v8 w=650000u l=150000u
X2 VPWR a_105_352# Y VPB sky130_fd_pr__pfet_01v8_hvt w=1e+06u l=150000u
X3 a_297_47# A2 VGND VNB sky130_fd_pr__nfet_01v8 w=650000u l=150000u
X4 a_388_297# A1 VPWR VPB sky130_fd_pr__pfet_01v8_hvt w=1e+06u l=150000u
X5 VGND B1_N a_105_352# VNB sky130_fd_pr__nfet_01v8 w=420000u l=150000u
X6 a_105_352# B1_N VPWR VPB sky130_fd_pr__pfet_01v8_hvt w=420000u l=150000u
X7 Y A2 a_388_297# VPB sky130_fd_pr__pfet_01v8_hvt w=1e+06u l=150000u
.ends
.subckt sky130_fd_sc_hd__o221ai_2 A1 A2 B1 B2 C1 VGND VNB VPB VPWR Y
X0 a_734_297# A2 Y VPB sky130_fd_pr__pfet_01v8_hvt w=1e+06u l=150000u
X1 a_300_47# B2 a_28_47# VNB sky130_fd_pr__nfet_01v8 w=650000u l=150000u
X2 a_734_297# A1 VPWR VPB sky130_fd_pr__pfet_01v8_hvt w=1e+06u l=150000u
X3 VPWR C1 Y VPB sky130_fd_pr__pfet_01v8_hvt w=1e+06u l=150000u
X4 Y A2 a_734_297# VPB sky130_fd_pr__pfet_01v8_hvt w=1e+06u l=150000u
X5 a_28_47# C1 Y VNB sky130_fd_pr__nfet_01v8 w=650000u l=150000u
X6 a_382_297# B2 Y VPB sky130_fd_pr__pfet_01v8_hvt w=1e+06u l=150000u
X7 Y C1 a_28_47# VNB sky130_fd_pr__nfet_01v8 w=650000u l=150000u
X8 a_28_47# B2 a_300_47# VNB sky130_fd_pr__nfet_01v8 w=650000u l=150000u
X9 VGND A1 a_300_47# VNB sky130_fd_pr__nfet_01v8 w=650000u l=150000u
X10 a_382_297# B1 VPWR VPB sky130_fd_pr__pfet_01v8_hvt w=1e+06u l=150000u
X11 VPWR B1 a_382_297# VPB sky130_fd_pr__pfet_01v8_hvt w=1e+06u l=150000u
X12 a_300_47# B1 a_28_47# VNB sky130_fd_pr__nfet_01v8 w=650000u l=150000u
X13 a_300_47# A2 VGND VNB sky130_fd_pr__nfet_01v8 w=650000u l=150000u
X14 Y B2 a_382_297# VPB sky130_fd_pr__pfet_01v8_hvt w=1e+06u l=150000u
X15 a_300_47# A1 VGND VNB sky130_fd_pr__nfet_01v8 w=650000u l=150000u
X16 VPWR A1 a_734_297# VPB sky130_fd_pr__pfet_01v8_hvt w=1e+06u l=150000u
X17 a_28_47# B1 a_300_47# VNB sky130_fd_pr__nfet_01v8 w=650000u l=150000u
X18 VGND A2 a_300_47# VNB sky130_fd_pr__nfet_01v8 w=650000u l=150000u
X19 Y C1 VPWR VPB sky130_fd_pr__pfet_01v8_hvt w=1e+06u l=150000u
.ends
.subckt sky130_fd_sc_hd__o22ai_1 A1 A2 B1 B2 VGND VNB VPB VPWR Y
X0 Y A2 a_307_297# VPB sky130_fd_pr__pfet_01v8_hvt w=1e+06u l=150000u
X1 a_307_297# A1 VPWR VPB sky130_fd_pr__pfet_01v8_hvt w=1e+06u l=150000u
X2 a_109_297# B2 Y VPB sky130_fd_pr__pfet_01v8_hvt w=1e+06u l=150000u
X3 a_27_47# A2 VGND VNB sky130_fd_pr__nfet_01v8 w=650000u l=150000u
X4 a_27_47# B1 Y VNB sky130_fd_pr__nfet_01v8 w=650000u l=150000u
X5 Y B2 a_27_47# VNB sky130_fd_pr__nfet_01v8 w=650000u l=150000u
X6 VPWR B1 a_109_297# VPB sky130_fd_pr__pfet_01v8_hvt w=1e+06u l=150000u
X7 VGND A1 a_27_47# VNB sky130_fd_pr__nfet_01v8 w=650000u l=150000u
.ends
.subckt sky130_fd_sc_hd__o2bb2ai_1 A1_N A2_N B1 B2 VGND VNB VPB VPWR Y
X0 a_112_297# A2_N VPWR VPB sky130_fd_pr__pfet_01v8_hvt w=1e+06u l=150000u
X1 Y B2 a_478_297# VPB sky130_fd_pr__pfet_01v8_hvt w=1e+06u l=150000u
X2 VGND B1 a_394_47# VNB sky130_fd_pr__nfet_01v8 w=650000u l=150000u
X3 VPWR A1_N a_112_297# VPB sky130_fd_pr__pfet_01v8_hvt w=1e+06u l=150000u
X4 VPWR a_112_297# Y VPB sky130_fd_pr__pfet_01v8_hvt w=1e+06u l=150000u
X5 a_478_297# B1 VPWR VPB sky130_fd_pr__pfet_01v8_hvt w=1e+06u l=150000u
X6 a_112_47# A2_N a_112_297# VNB sky130_fd_pr__nfet_01v8 w=650000u l=150000u
X7 a_394_47# B2 VGND VNB sky130_fd_pr__nfet_01v8 w=650000u l=150000u
X8 VGND A1_N a_112_47# VNB sky130_fd_pr__nfet_01v8 w=650000u l=150000u
X9 Y a_112_297# a_394_47# VNB sky130_fd_pr__nfet_01v8 w=650000u l=150000u
.ends
.subckt sky130_fd_sc_hd__o32ai_1 A1 A2 A3 B1 B2 VGND VNB VPB VPWR Y
X0 a_109_297# B2 Y VPB sky130_fd_pr__pfet_01v8_hvt w=1e+06u l=150000u
X1 a_461_297# A1 VPWR VPB sky130_fd_pr__pfet_01v8_hvt w=1e+06u l=150000u
X2 a_333_297# A2 a_461_297# VPB sky130_fd_pr__pfet_01v8_hvt w=1e+06u l=150000u
X3 Y B2 a_27_47# VNB sky130_fd_pr__nfet_01v8 w=650000u l=150000u
X4 a_27_47# A3 VGND VNB sky130_fd_pr__nfet_01v8 w=650000u l=150000u
X5 Y A3 a_333_297# VPB sky130_fd_pr__pfet_01v8_hvt w=1e+06u l=150000u
X6 a_27_47# B1 Y VNB sky130_fd_pr__nfet_01v8 w=650000u l=150000u
X7 a_27_47# A1 VGND VNB sky130_fd_pr__nfet_01v8 w=650000u l=150000u
X8 VPWR B1 a_109_297# VPB sky130_fd_pr__pfet_01v8_hvt w=1e+06u l=150000u
X9 VGND A2 a_27_47# VNB sky130_fd_pr__nfet_01v8 w=650000u l=150000u
.ends
.subckt sky130_fd_sc_hd__or4_1 A B C D VGND VNB VPB VPWR X
X0 a_27_297# A VGND VNB sky130_fd_pr__nfet_01v8 w=420000u l=150000u
X1 VGND D a_27_297# VNB sky130_fd_pr__nfet_01v8 w=420000u l=150000u
X2 VGND B a_27_297# VNB sky130_fd_pr__nfet_01v8 w=420000u l=150000u
X3 VGND a_27_297# X VNB sky130_fd_pr__nfet_01v8 w=650000u l=150000u
X4 a_109_297# C a_205_297# VPB sky130_fd_pr__pfet_01v8_hvt w=420000u l=150000u
X5 a_205_297# B a_277_297# VPB sky130_fd_pr__pfet_01v8_hvt w=420000u l=150000u
X6 a_27_297# C VGND VNB sky130_fd_pr__nfet_01v8 w=420000u l=150000u
X7 a_277_297# A VPWR VPB sky130_fd_pr__pfet_01v8_hvt w=420000u l=150000u
X8 a_27_297# D a_109_297# VPB sky130_fd_pr__pfet_01v8_hvt w=420000u l=150000u
X9 VPWR a_27_297# X VPB sky130_fd_pr__pfet_01v8_hvt w=1e+06u l=150000u
.ends
.subckt sky130_fd_sc_hd__or4b_1 A B C D_N VGND VNB VPB VPWR X
X0 VGND a_109_53# a_215_297# VNB sky130_fd_pr__nfet_01v8 w=420000u l=150000u
X1 a_215_297# A VGND VNB sky130_fd_pr__nfet_01v8 w=420000u l=150000u
X2 VGND B a_215_297# VNB sky130_fd_pr__nfet_01v8 w=420000u l=150000u
X3 a_297_297# C a_392_297# VPB sky130_fd_pr__pfet_01v8_hvt w=420000u l=150000u
X4 a_215_297# a_109_53# a_297_297# VPB sky130_fd_pr__pfet_01v8_hvt w=420000u l=150000u
X5 a_392_297# B a_465_297# VPB sky130_fd_pr__pfet_01v8_hvt w=420000u l=150000u
X6 VGND a_215_297# X VNB sky130_fd_pr__nfet_01v8 w=650000u l=150000u
X7 VGND D_N a_109_53# VNB sky130_fd_pr__nfet_01v8 w=420000u l=150000u
X8 a_215_297# C VGND VNB sky130_fd_pr__nfet_01v8 w=420000u l=150000u
X9 VPWR D_N a_109_53# VPB sky130_fd_pr__pfet_01v8_hvt w=420000u l=150000u
X10 a_465_297# A VPWR VPB sky130_fd_pr__pfet_01v8_hvt w=420000u l=150000u
X11 VPWR a_215_297# X VPB sky130_fd_pr__pfet_01v8_hvt w=1e+06u l=150000u
.ends
.subckt sky130_fd_sc_hd__sdfxtp_1 CLK D SCD SCE VGND VNB VPB VPWR Q
X0 a_1478_47# a_1520_315# VGND VNB sky130_fd_pr__nfet_01v8 w=420000u l=150000u
X1 a_27_47# CLK VPWR VPB sky130_fd_pr__pfet_01v8_hvt w=640000u l=150000u
X2 a_1092_183# a_193_47# a_1349_413# VNB sky130_fd_pr__special_nfet_01v8 w=360000u l=150000u
X3 a_1520_315# a_1349_413# VGND VNB sky130_fd_pr__nfet_01v8 w=650000u l=150000u
X4 VPWR SCE a_467_369# VPB sky130_fd_pr__pfet_01v8_hvt w=640000u l=150000u
X5 a_1433_413# a_1520_315# VPWR VPB sky130_fd_pr__pfet_01v8_hvt w=420000u l=150000u
X6 a_1030_47# a_1092_183# VGND VNB sky130_fd_pr__nfet_01v8 w=420000u l=150000u
X7 VPWR a_1520_315# Q VPB sky130_fd_pr__pfet_01v8_hvt w=1e+06u l=150000u
X8 a_299_47# SCE VPWR VPB sky130_fd_pr__pfet_01v8_hvt w=640000u l=150000u
X9 a_933_413# a_193_47# a_1030_47# VNB sky130_fd_pr__special_nfet_01v8 w=360000u l=150000u
X10 a_640_369# SCD VPWR VPB sky130_fd_pr__pfet_01v8_hvt w=640000u l=150000u
X11 a_1092_183# a_27_47# a_1349_413# VPB sky130_fd_pr__pfet_01v8_hvt w=420000u l=150000u
X12 a_483_47# D a_556_369# VNB sky130_fd_pr__nfet_01v8 w=420000u l=150000u
X13 a_467_369# D a_556_369# VPB sky130_fd_pr__pfet_01v8_hvt w=640000u l=150000u
X14 a_299_47# SCE VGND VNB sky130_fd_pr__nfet_01v8 w=420000u l=150000u
X15 a_556_369# SCE a_657_47# VNB sky130_fd_pr__nfet_01v8 w=420000u l=150000u
X16 a_1026_413# a_1092_183# VPWR VPB sky130_fd_pr__pfet_01v8_hvt w=420000u l=150000u
X17 a_1349_413# a_193_47# a_1433_413# VPB sky130_fd_pr__pfet_01v8_hvt w=420000u l=150000u
X18 VGND a_27_47# a_193_47# VNB sky130_fd_pr__nfet_01v8 w=420000u l=150000u
X19 a_27_47# CLK VGND VNB sky130_fd_pr__nfet_01v8 w=420000u l=150000u
X20 VGND a_933_413# a_1092_183# VNB sky130_fd_pr__nfet_01v8 w=640000u l=150000u
X21 VGND a_1520_315# Q VNB sky130_fd_pr__nfet_01v8 w=650000u l=150000u
X22 a_1520_315# a_1349_413# VPWR VPB sky130_fd_pr__pfet_01v8_hvt w=1e+06u l=150000u
X23 a_556_369# a_299_47# a_640_369# VPB sky130_fd_pr__pfet_01v8_hvt w=640000u l=150000u
X24 a_556_369# a_193_47# a_933_413# VPB sky130_fd_pr__pfet_01v8_hvt w=420000u l=150000u
X25 VPWR a_27_47# a_193_47# VPB sky130_fd_pr__pfet_01v8_hvt w=640000u l=150000u
X26 a_657_47# SCD VGND VNB sky130_fd_pr__nfet_01v8 w=420000u l=150000u
X27 VGND a_299_47# a_483_47# VNB sky130_fd_pr__nfet_01v8 w=420000u l=150000u
X28 VPWR a_933_413# a_1092_183# VPB sky130_fd_pr__pfet_01v8_hvt w=750000u l=150000u
X29 a_933_413# a_27_47# a_1026_413# VPB sky130_fd_pr__pfet_01v8_hvt w=420000u l=150000u
X30 a_556_369# a_27_47# a_933_413# VNB sky130_fd_pr__special_nfet_01v8 w=360000u l=150000u
X31 a_1349_413# a_27_47# a_1478_47# VNB sky130_fd_pr__special_nfet_01v8 w=360000u l=150000u
.ends
.subckt sky130_fd_sc_hd__tapvpwrvgnd_1 VGND VPWR
.ends
.subckt sky130_fd_sc_hd__xnor2_1 A B VGND VNB VPB VPWR Y
X0 VPWR A a_377_297# VPB sky130_fd_pr__pfet_01v8_hvt w=1e+06u l=150000u
X1 a_377_297# B Y VPB sky130_fd_pr__pfet_01v8_hvt w=1e+06u l=150000u
X2 Y a_47_47# VPWR VPB sky130_fd_pr__pfet_01v8_hvt w=1e+06u l=150000u
X3 a_129_47# A VGND VNB sky130_fd_pr__nfet_01v8 w=650000u l=150000u
X4 VGND B a_285_47# VNB sky130_fd_pr__nfet_01v8 w=650000u l=150000u
X5 a_47_47# B a_129_47# VNB sky130_fd_pr__nfet_01v8 w=650000u l=150000u
X6 VPWR B a_47_47# VPB sky130_fd_pr__pfet_01v8_hvt w=1e+06u l=150000u
X7 a_47_47# A VPWR VPB sky130_fd_pr__pfet_01v8_hvt w=1e+06u l=150000u
X8 VGND A a_285_47# VNB sky130_fd_pr__nfet_01v8 w=650000u l=150000u
X9 a_285_47# a_47_47# Y VNB sky130_fd_pr__nfet_01v8 w=650000u l=150000u
.ends
.subckt sky130_fd_sc_hd__xnor2_2 A B VGND VNB VPB VPWR Y
X0 VPWR B a_27_297# VPB sky130_fd_pr__pfet_01v8_hvt w=1e+06u l=150000u
X1 VGND B a_560_47# VNB sky130_fd_pr__nfet_01v8 w=650000u l=150000u
X2 VPWR A a_27_297# VPB sky130_fd_pr__pfet_01v8_hvt w=1e+06u l=150000u
X3 Y B a_474_297# VPB sky130_fd_pr__pfet_01v8_hvt w=1e+06u l=150000u
X4 a_27_297# A VPWR VPB sky130_fd_pr__pfet_01v8_hvt w=1e+06u l=150000u
X5 VPWR A a_474_297# VPB sky130_fd_pr__pfet_01v8_hvt w=1e+06u l=150000u
X6 a_27_297# B VPWR VPB sky130_fd_pr__pfet_01v8_hvt w=1e+06u l=150000u
X7 VGND A a_27_47# VNB sky130_fd_pr__nfet_01v8 w=650000u l=150000u
X8 a_474_297# A VPWR VPB sky130_fd_pr__pfet_01v8_hvt w=1e+06u l=150000u
X9 a_27_47# A VGND VNB sky130_fd_pr__nfet_01v8 w=650000u l=150000u
X10 Y a_27_297# VPWR VPB sky130_fd_pr__pfet_01v8_hvt w=1e+06u l=150000u
X11 a_474_297# B Y VPB sky130_fd_pr__pfet_01v8_hvt w=1e+06u l=150000u
X12 a_560_47# B VGND VNB sky130_fd_pr__nfet_01v8 w=650000u l=150000u
X13 VPWR a_27_297# Y VPB sky130_fd_pr__pfet_01v8_hvt w=1e+06u l=150000u
X14 a_27_47# B a_27_297# VNB sky130_fd_pr__nfet_01v8 w=650000u l=150000u
X15 a_560_47# A VGND VNB sky130_fd_pr__nfet_01v8 w=650000u l=150000u
X16 Y a_27_297# a_560_47# VNB sky130_fd_pr__nfet_01v8 w=650000u l=150000u
X17 a_27_297# B a_27_47# VNB sky130_fd_pr__nfet_01v8 w=650000u l=150000u
X18 VGND A a_560_47# VNB sky130_fd_pr__nfet_01v8 w=650000u l=150000u
X19 a_560_47# a_27_297# Y VNB sky130_fd_pr__nfet_01v8 w=650000u l=150000u
.ends
.subckt sky130_fd_sc_hd__xor2_1 A B VGND VNB VPB VPWR X
X0 a_35_297# A VGND VNB sky130_fd_pr__nfet_01v8 w=650000u l=150000u
X1 VGND B a_35_297# VNB sky130_fd_pr__nfet_01v8 w=650000u l=150000u
X2 X a_35_297# VGND VNB sky130_fd_pr__nfet_01v8 w=650000u l=150000u
X3 a_285_297# B VPWR VPB sky130_fd_pr__pfet_01v8_hvt w=1e+06u l=150000u
X4 VPWR A a_285_297# VPB sky130_fd_pr__pfet_01v8_hvt w=1e+06u l=150000u
X5 a_35_297# B a_117_297# VPB sky130_fd_pr__pfet_01v8_hvt w=1e+06u l=150000u
X6 a_117_297# A VPWR VPB sky130_fd_pr__pfet_01v8_hvt w=1e+06u l=150000u
X7 a_285_47# B X VNB sky130_fd_pr__nfet_01v8 w=650000u l=150000u
X8 a_285_297# a_35_297# X VPB sky130_fd_pr__pfet_01v8_hvt w=1e+06u l=150000u
X9 VGND A a_285_47# VNB sky130_fd_pr__nfet_01v8 w=650000u l=150000u
.ends
.subckt sky130_fd_sc_hd__xor2_2 A B VGND VNB VPB VPWR X
X0 VPWR A a_27_297# VPB sky130_fd_pr__pfet_01v8_hvt w=1e+06u l=150000u
X1 a_112_47# B a_27_297# VPB sky130_fd_pr__pfet_01v8_hvt w=1e+06u l=150000u
X2 X a_112_47# a_470_297# VPB sky130_fd_pr__pfet_01v8_hvt w=1e+06u l=150000u
X3 a_27_297# B a_112_47# VPB sky130_fd_pr__pfet_01v8_hvt w=1e+06u l=150000u
X4 a_470_297# B VPWR VPB sky130_fd_pr__pfet_01v8_hvt w=1e+06u l=150000u
X5 a_27_297# A VPWR VPB sky130_fd_pr__pfet_01v8_hvt w=1e+06u l=150000u
X6 a_112_47# B VGND VNB sky130_fd_pr__nfet_01v8 w=650000u l=150000u
X7 VGND A a_470_47# VNB sky130_fd_pr__nfet_01v8 w=650000u l=150000u
X8 X a_112_47# VGND VNB sky130_fd_pr__nfet_01v8 w=650000u l=150000u
X9 a_470_47# B X VNB sky130_fd_pr__nfet_01v8 w=650000u l=150000u
X10 VGND B a_112_47# VNB sky130_fd_pr__nfet_01v8 w=650000u l=150000u
X11 a_470_47# A VGND VNB sky130_fd_pr__nfet_01v8 w=650000u l=150000u
X12 a_470_297# a_112_47# X VPB sky130_fd_pr__pfet_01v8_hvt w=1e+06u l=150000u
X13 VPWR A a_470_297# VPB sky130_fd_pr__pfet_01v8_hvt w=1e+06u l=150000u
X14 a_470_297# A VPWR VPB sky130_fd_pr__pfet_01v8_hvt w=1e+06u l=150000u
X15 VGND A a_112_47# VNB sky130_fd_pr__nfet_01v8 w=650000u l=150000u
X16 X B a_470_47# VNB sky130_fd_pr__nfet_01v8 w=650000u l=150000u
X17 a_112_47# A VGND VNB sky130_fd_pr__nfet_01v8 w=650000u l=150000u
X18 VPWR B a_470_297# VPB sky130_fd_pr__pfet_01v8_hvt w=1e+06u l=150000u
X19 VGND a_112_47# X VNB sky130_fd_pr__nfet_01v8 w=650000u l=150000u
.ends
.subckt adc_readout VGND VPWR clk cs_n dbg_mode[0] dbg_mode[1] debug[0] debug[1] debug[2] debug[3] debug[4] debug[5] debug[6] debug[7] err_clr osr_sel rst_n sclk sdo tap_n[0] tap_n[10] tap_n[11] tap_n[12] tap_n[13] tap_n[14] tap_n[1] tap_n[2] tap_n[3] tap_n[4] tap_n[5] tap_n[6] tap_n[7] tap_n[8] tap_n[9] tap_p[0] tap_p[10] tap_p[11] tap_p[12] tap_p[13] tap_p[14] tap_p[1] tap_p[2] tap_p[3] tap_p[4] tap_p[5] tap_p[6] tap_p[7] tap_p[8] tap_p[9] wrap_err
X_115_ pp.f5.sum VGND VGND VPWR VPWR _011_ sky130_fd_sc_hd__inv_1
X_116_ pp.f4.sum VGND VGND VPWR VPWR _012_ sky130_fd_sc_hd__inv_1
X_117_ pn.f5.co VGND VGND VPWR VPWR _013_ sky130_fd_sc_hd__inv_1
X_118_ phase[7] VGND VGND VPWR VPWR _014_ sky130_fd_sc_hd__inv_1
X_119_ vn.count[0] VGND VGND VPWR VPWR _111_[0] sky130_fd_sc_hd__inv_1
X_120_ vp.count[0] VGND VGND VPWR VPWR _113_[0] sky130_fd_sc_hd__inv_1
X_121_ pp.f5.sum pp.f5.co pp.f4.sum VGND VGND VPWR VPWR _015_ sky130_fd_sc_hd__nand3_1
X_122_ pn.f5.sum pn.f5.co pn.f4.sum VGND VGND VPWR VPWR _016_ sky130_fd_sc_hd__nand3_1
X_123_ _015_ _016_ VGND VGND VPWR VPWR _017_ sky130_fd_sc_hd__nand2_1
X_124_ valid[3] _017_ wrap_err VGND VGND VPWR VPWR _018_ sky130_fd_sc_hd__a21oi_1
X_125_ clear_sync[1] _018_ VGND VGND VPWR VPWR _004_ sky130_fd_sc_hd__nor2_1
X_126_ phase[5] phase[4] VGND VGND VPWR VPWR _019_ sky130_fd_sc_hd__lpflow_isobufsrc_1
X_127_ phase[3] rate VGND VGND VPWR VPWR _020_ sky130_fd_sc_hd__nand2b_1
X_128_ rate phase[3] VGND VGND VPWR VPWR _021_ sky130_fd_sc_hd__nand2b_1
X_129_ rate phase[3] VGND VGND VPWR VPWR _022_ sky130_fd_sc_hd__xor2_1
X_130_ work[18] work[17] phase[2] VGND VGND VPWR VPWR _023_ sky130_fd_sc_hd__mux2i_1
X_131_ work[20] work[19] phase[2] VGND VGND VPWR VPWR _024_ sky130_fd_sc_hd__mux2i_1
X_132_ phase[2] phase[3] VGND VGND VPWR VPWR _025_ sky130_fd_sc_hd__lpflow_isobufsrc_1
X_133_ phase[2] phase[3] VGND VGND VPWR VPWR _026_ sky130_fd_sc_hd__nor2_1
X_134_ _020_ _024_ VGND VGND VPWR VPWR _027_ sky130_fd_sc_hd__nor2_1
X_135_ work[16] work[15] phase[2] VGND VGND VPWR VPWR _028_ sky130_fd_sc_hd__mux2i_2
X_136_ _022_ _023_ _028_ _021_ VGND VGND VPWR VPWR _029_ sky130_fd_sc_hd__o22ai_1
X_137_ _027_ _029_ _019_ VGND VGND VPWR VPWR _030_ sky130_fd_sc_hd__o21ai_0
X_138_ work[14] work[13] phase[2] VGND VGND VPWR VPWR _031_ sky130_fd_sc_hd__mux2i_1
X_139_ _022_ _031_ VGND VGND VPWR VPWR _032_ sky130_fd_sc_hd__nor2_1
X_140_ work[12] work[11] phase[2] VGND VGND VPWR VPWR _033_ sky130_fd_sc_hd__mux2i_2
X_141_ _020_ _028_ _033_ _021_ VGND VGND VPWR VPWR _034_ sky130_fd_sc_hd__o22ai_1
X_142_ _032_ _034_ phase[5] phase[4] VGND VGND VPWR VPWR _035_ sky130_fd_sc_hd__o211ai_1
X_143_ phase[0] phase[1] VGND VGND VPWR VPWR _036_ sky130_fd_sc_hd__nor2_1
X_144_ _030_ _035_ _036_ VGND VGND VPWR VPWR _037_ sky130_fd_sc_hd__and3_1
X_145_ work[4] work[6] work[3] work[5] rate phase[2] VGND VGND VPWR VPWR _038_ sky130_fd_sc_hd__mux4_1
X_146_ phase[3] _038_ VGND VGND VPWR VPWR _039_ sky130_fd_sc_hd__and2_0
X_147_ work[7] _025_ _026_ work[8] VGND VGND VPWR VPWR _040_ sky130_fd_sc_hd__a22oi_1
X_148_ work[5] _025_ _026_ work[6] VGND VGND VPWR VPWR _041_ sky130_fd_sc_hd__a22oi_1
X_149_ _041_ _040_ rate VGND VGND VPWR VPWR _042_ sky130_fd_sc_hd__mux2i_1
X_150_ phase[4] phase[5] VGND VGND VPWR VPWR _043_ sky130_fd_sc_hd__lpflow_isobufsrc_1
X_151_ _039_ _042_ _043_ VGND VGND VPWR VPWR _044_ sky130_fd_sc_hd__o21ai_1
X_152_ work[8] work[10] work[7] work[9] rate phase[2] VGND VGND VPWR VPWR _045_ sky130_fd_sc_hd__mux4_1
X_153_ phase[3] _045_ VGND VGND VPWR VPWR _046_ sky130_fd_sc_hd__nand2_1
X_154_ work[9] _025_ _026_ work[10] VGND VGND VPWR VPWR _047_ sky130_fd_sc_hd__a22oi_1
X_155_ _020_ _033_ _047_ rate _046_ VGND VGND VPWR VPWR _048_ sky130_fd_sc_hd__o221ai_2
X_156_ phase[5] phase[4] VGND VGND VPWR VPWR _049_ sky130_fd_sc_hd__nor2_1
X_157_ _048_ _049_ VGND VGND VPWR VPWR _050_ sky130_fd_sc_hd__nand2_1
X_158_ phase[6] phase[7] VGND VGND VPWR VPWR _051_ sky130_fd_sc_hd__nor2_1
X_159_ phase[7] phase[5] phase[6] VGND VGND VPWR VPWR _052_ sky130_fd_sc_hd__nor3b_1
X_160_ phase[5] _051_ _052_ VGND VGND VPWR VPWR _053_ sky130_fd_sc_hd__a21o_1
X_161_ sampled _053_ VGND VGND VPWR VPWR _001_ sky130_fd_sc_hd__nand2_1
X_162_ sdo _036_ _001_ VGND VGND VPWR VPWR _054_ sky130_fd_sc_hd__o21bai_1
X_163_ _037_ _044_ _050_ _054_ VGND VGND VPWR VPWR _005_ sky130_fd_sc_hd__a31oi_1
X_164_ phase[1] phase[2] phase[3] phase[0] VGND VGND VPWR VPWR _055_ sky130_fd_sc_hd__nor4b_2
X_165_ phase[6] phase[7] phase[5] phase[4] VGND VGND VPWR VPWR _056_ sky130_fd_sc_hd__or4_1
X_166_ sampled _049_ _051_ _055_ VGND VGND VPWR VPWR _057_ sky130_fd_sc_hd__nand4_4
X_167_ _057_ VGND VGND VPWR VPWR capture sky130_fd_sc_hd__clkinv_8
X_168_ phase[1] phase[2] phase[3] VGND VGND VPWR VPWR _058_ sky130_fd_sc_hd__nor3_1
X_169_ phase[6] phase[7] phase[5] phase[4] VGND VGND VPWR VPWR _059_ sky130_fd_sc_hd__or4b_1
X_170_ phase[0] phase[1] phase[2] VGND VGND VPWR VPWR _060_ sky130_fd_sc_hd__and3_1
X_171_ phase[3] _060_ VGND VGND VPWR VPWR _061_ sky130_fd_sc_hd__nor2_1
X_172_ phase[3] _059_ _060_ _056_ _058_ VGND VGND VPWR VPWR _062_ sky130_fd_sc_hd__o32ai_1
X_173_ sampled _062_ VGND VGND VPWR VPWR _063_ sky130_fd_sc_hd__nand2_1
X_174_ _063_ VGND VGND VPWR VPWR g_delay.en sky130_fd_sc_hd__inv_1
X_175_ capture g_delay.en VGND VGND VPWR VPWR _064_ sky130_fd_sc_hd__nor2_1
X_176_ _064_ VGND VGND VPWR VPWR g_work.en sky130_fd_sc_hd__inv_1
X_177_ history_valid delay1[0] VGND VGND VPWR VPWR _065_ sky130_fd_sc_hd__nand2_1
X_178_ a _065_ VGND VGND VPWR VPWR _066_ sky130_fd_sc_hd__nor2_1
X_179_ a _065_ VGND VGND VPWR VPWR _067_ sky130_fd_sc_hd__xor2_2
X_180_ borrow1 _067_ _066_ VGND VGND VPWR VPWR _068_ sky130_fd_sc_hd__a21oi_1
X_181_ borrow1 _064_ _068_ _063_ VGND VGND VPWR VPWR _006_ sky130_fd_sc_hd__o2bb2ai_1
X_182_ net30 _067_ VGND VGND VPWR VPWR _069_ sky130_fd_sc_hd__xor2_2
X_183_ _069_ VGND VGND VPWR VPWR first sky130_fd_sc_hd__inv_1
X_184_ history_valid delay2[0] VGND VGND VPWR VPWR _070_ sky130_fd_sc_hd__and2_0
X_185_ _069_ _070_ VGND VGND VPWR VPWR _071_ sky130_fd_sc_hd__xor2_1
X_186_ borrow2 _069_ _070_ VGND VGND VPWR VPWR _072_ sky130_fd_sc_hd__maj3_1
X_187_ borrow2 _064_ _072_ g_delay.en VGND VGND VPWR VPWR _007_ sky130_fd_sc_hd__a22o_1
X_188_ phase[6] _014_ _019_ _055_ VGND VGND VPWR VPWR _073_ sky130_fd_sc_hd__nand4_2
X_189_ rate rate_sync[1] VGND VGND VPWR VPWR _074_ sky130_fd_sc_hd__xnor2_2
X_190_ sampled _073_ _074_ VGND VGND VPWR VPWR _075_ sky130_fd_sc_hd__a21oi_4
X_191_ _075_ VGND VGND VPWR VPWR _000_ sky130_fd_sc_hd__inv_1
X_192_ phase[0] phase[1] _025_ sampled VGND VGND VPWR VPWR _076_ sky130_fd_sc_hd__nand4b_1
X_193_ history_valid _000_ _076_ _059_ VGND VGND VPWR VPWR _008_ sky130_fd_sc_hd__o2bb2ai_1
X_194_ rate rate_sync[1] _075_ VGND VGND VPWR VPWR _009_ sky130_fd_sc_hd__mux2_1
X_195_ phase[0] phase[1] phase[2] phase[3] VGND VGND VPWR VPWR _077_ sky130_fd_sc_hd__and4_2
X_196_ phase[6] phase[5] phase[4] _077_ VGND VGND VPWR VPWR _078_ sky130_fd_sc_hd__and4_1
X_197_ rate _014_ _078_ VGND VGND VPWR VPWR _079_ sky130_fd_sc_hd__a21boi_1
X_198_ sampled _079_ VGND VGND VPWR VPWR _080_ sky130_fd_sc_hd__nor2_1
X_199_ _075_ _080_ VGND VGND VPWR VPWR _010_ sky130_fd_sc_hd__nor2_1
X_200_ dbg_mode[1] dbg_mode[0] VGND VGND VPWR VPWR vn.cg.en sky130_fd_sc_hd__lpflow_isobufsrc_1
X_201_ pp.f1.sum pn.f1.sum VGND VGND VPWR VPWR _081_ sky130_fd_sc_hd__lpflow_isobufsrc_1
X_202_ pn.f1.sum pp.f1.sum VGND VGND VPWR VPWR _082_ sky130_fd_sc_hd__lpflow_isobufsrc_1
X_203_ _081_ _082_ valid[3] VGND VGND VPWR VPWR add1.bit_add[0].fa.b sky130_fd_sc_hd__o21a_1
X_204_ pp.f4.sum pn.f4.sum VGND VGND VPWR VPWR _083_ sky130_fd_sc_hd__xor2_1
X_205_ _082_ _083_ VGND VGND VPWR VPWR _084_ sky130_fd_sc_hd__nor2_1
X_206_ _082_ _083_ VGND VGND VPWR VPWR _085_ sky130_fd_sc_hd__nand2_1
X_207_ valid[3] _085_ VGND VGND VPWR VPWR _086_ sky130_fd_sc_hd__nand2_1
X_208_ _084_ _086_ VGND VGND VPWR VPWR add1.bit_add[1].fa.b sky130_fd_sc_hd__nor2_1
X_209_ _012_ pn.f4.sum _082_ VGND VGND VPWR VPWR _087_ sky130_fd_sc_hd__maj3_1
X_210_ pp.f5.sum pn.f5.sum VGND VGND VPWR VPWR _088_ sky130_fd_sc_hd__xnor2_1
X_211_ _087_ _088_ VGND VGND VPWR VPWR _089_ sky130_fd_sc_hd__xnor2_1
X_212_ valid[3] _089_ VGND VGND VPWR VPWR add1.bit_add[2].fa.b sky130_fd_sc_hd__and2_0
X_213_ _011_ pn.f5.sum _087_ VGND VGND VPWR VPWR _090_ sky130_fd_sc_hd__maj3_1
X_214_ pp.f5.co pn.f5.co VGND VGND VPWR VPWR _091_ sky130_fd_sc_hd__xor2_1
X_215_ _090_ _091_ valid[3] VGND VGND VPWR VPWR _092_ sky130_fd_sc_hd__o21ai_2
X_216_ _090_ _091_ _092_ VGND VGND VPWR VPWR add1.bit_add[3].fa.b sky130_fd_sc_hd__a21oi_1
X_217_ pp.f5.co _013_ _092_ VGND VGND VPWR VPWR add1.bit_add[10].fa.b sky130_fd_sc_hd__a21oi_4
X_218_ dbg_mode[0] valid[3] VGND VGND VPWR VPWR _093_ sky130_fd_sc_hd__nand2_1
X_219_ dbg_mode[1] _093_ VGND VGND VPWR VPWR _094_ sky130_fd_sc_hd__nor2_1
X_220_ dbg_mode[1] _093_ VGND VGND VPWR VPWR _095_ sky130_fd_sc_hd__lpflow_inputiso1p_1
X_221_ vp.divided vn.cg.en _094_ pn.f1.sum VGND VGND VPWR VPWR debug[0] sky130_fd_sc_hd__a22o_1
X_222_ vn.divided vn.cg.en _094_ pn.f4.sum VGND VGND VPWR VPWR debug[1] sky130_fd_sc_hd__a22o_2
X_223_ pn.f5.sum _094_ VGND VGND VPWR VPWR debug[2] sky130_fd_sc_hd__and2_1
X_224_ _013_ _095_ VGND VGND VPWR VPWR debug[3] sky130_fd_sc_hd__nor2_2
X_225_ pp.f1.sum _094_ VGND VGND VPWR VPWR debug[4] sky130_fd_sc_hd__and2_1
X_226_ _012_ _095_ VGND VGND VPWR VPWR debug[5] sky130_fd_sc_hd__nor2_2
X_227_ _011_ _095_ VGND VGND VPWR VPWR debug[6] sky130_fd_sc_hd__nor2_2
X_228_ pp.f5.co _094_ VGND VGND VPWR VPWR debug[7] sky130_fd_sc_hd__and2_2
X_229_ phase[0] _075_ VGND VGND VPWR VPWR _002_[0] sky130_fd_sc_hd__nor2_1
X_230_ phase[0] phase[1] VGND VGND VPWR VPWR _096_ sky130_fd_sc_hd__xnor2_1
X_231_ _075_ _096_ VGND VGND VPWR VPWR _002_[1] sky130_fd_sc_hd__nor2_1
X_232_ phase[0] phase[1] phase[2] VGND VGND VPWR VPWR _097_ sky130_fd_sc_hd__a21oi_1
X_233_ _060_ _075_ _097_ VGND VGND VPWR VPWR _002_[2] sky130_fd_sc_hd__nor3_1
X_234_ _061_ _075_ _077_ VGND VGND VPWR VPWR _002_[3] sky130_fd_sc_hd__nor3_1
X_235_ phase[4] _077_ VGND VGND VPWR VPWR _098_ sky130_fd_sc_hd__nand2_1
X_236_ phase[4] _077_ VGND VGND VPWR VPWR _099_ sky130_fd_sc_hd__xnor2_1
X_237_ _075_ _099_ VGND VGND VPWR VPWR _002_[4] sky130_fd_sc_hd__nor2_1
X_238_ phase[5] _098_ VGND VGND VPWR VPWR _100_ sky130_fd_sc_hd__xor2_1
X_239_ _075_ _100_ VGND VGND VPWR VPWR _002_[5] sky130_fd_sc_hd__nor2_1
X_240_ phase[5] phase[4] _077_ phase[6] VGND VGND VPWR VPWR _101_ sky130_fd_sc_hd__a31oi_1
X_241_ _075_ _078_ _101_ VGND VGND VPWR VPWR _002_[6] sky130_fd_sc_hd__nor3_1
X_242_ phase[7] _078_ VGND VGND VPWR VPWR _102_ sky130_fd_sc_hd__nor2_1
X_243_ _075_ _079_ _102_ VGND VGND VPWR VPWR _002_[7] sky130_fd_sc_hd__nor3_1
X_244_ vp.count[0] vp.count[1] VGND VGND VPWR VPWR _103_ sky130_fd_sc_hd__nand2_1
X_245_ vp.count[0] vp.count[1] VGND VGND VPWR VPWR _114_[1] sky130_fd_sc_hd__xor2_1
X_246_ vp.count[2] _103_ VGND VGND VPWR VPWR _114_[2] sky130_fd_sc_hd__xnor2_1
X_247_ vp.count[0] vp.count[1] vp.count[2] vp.count[3] VGND VGND VPWR VPWR _104_ sky130_fd_sc_hd__nand4_2
X_248_ vp.count[0] vp.count[1] vp.count[2] vp.count[3] VGND VGND VPWR VPWR _105_ sky130_fd_sc_hd__a31oi_1
X_249_ _104_ _105_ VGND VGND VPWR VPWR _114_[3] sky130_fd_sc_hd__lpflow_isobufsrc_1
X_250_ vp.count[4] _104_ VGND VGND VPWR VPWR _106_ sky130_fd_sc_hd__lpflow_isobufsrc_1
X_251_ vp.count[4] _104_ VGND VGND VPWR VPWR _114_[4] sky130_fd_sc_hd__xnor2_1
X_252_ vp.divided _106_ VGND VGND VPWR VPWR _114_[5] sky130_fd_sc_hd__xor2_1
X_253_ phase[1] _001_ VGND VGND VPWR VPWR _003_ sky130_fd_sc_hd__lpflow_isobufsrc_1
X_254_ sync[0] prev[0] VGND VGND VPWR VPWR pn.column[0].fa.a sky130_fd_sc_hd__xor2_1
X_255_ sync[1] prev[1] VGND VGND VPWR VPWR pn.column[0].fa.b sky130_fd_sc_hd__xor2_1
X_256_ sync[2] prev[2] VGND VGND VPWR VPWR pn.column[0].fa.ci sky130_fd_sc_hd__xor2_1
X_257_ sync[3] prev[3] VGND VGND VPWR VPWR pn.column[1].fa.a sky130_fd_sc_hd__xor2_1
X_258_ sync[4] prev[4] VGND VGND VPWR VPWR pn.column[1].fa.b sky130_fd_sc_hd__xor2_1
X_259_ sync[5] prev[5] VGND VGND VPWR VPWR pn.column[1].fa.ci sky130_fd_sc_hd__xor2_1
X_260_ sync[6] prev[6] VGND VGND VPWR VPWR pn.column[2].fa.a sky130_fd_sc_hd__xor2_1
X_261_ sync[7] prev[7] VGND VGND VPWR VPWR pn.column[2].fa.b sky130_fd_sc_hd__xor2_1
X_262_ sync[8] prev[8] VGND VGND VPWR VPWR pn.column[2].fa.ci sky130_fd_sc_hd__xor2_1
X_263_ sync[9] prev[9] VGND VGND VPWR VPWR pn.column[3].fa.a sky130_fd_sc_hd__xor2_1
X_264_ sync[10] prev[10] VGND VGND VPWR VPWR pn.column[3].fa.b sky130_fd_sc_hd__xor2_1
X_265_ sync[11] prev[11] VGND VGND VPWR VPWR pn.column[3].fa.ci sky130_fd_sc_hd__xor2_1
X_266_ sync[12] prev[12] VGND VGND VPWR VPWR pn.column[4].fa.a sky130_fd_sc_hd__xor2_1
X_267_ sync[13] prev[13] VGND VGND VPWR VPWR pn.column[4].fa.b sky130_fd_sc_hd__xor2_1
X_268_ sync[14] prev[14] VGND VGND VPWR VPWR pn.column[4].fa.ci sky130_fd_sc_hd__xor2_1
X_269_ sync[15] prev[15] VGND VGND VPWR VPWR pp.column[0].fa.a sky130_fd_sc_hd__xor2_1
X_270_ sync[16] prev[16] VGND VGND VPWR VPWR pp.column[0].fa.b sky130_fd_sc_hd__xor2_1
X_271_ sync[17] prev[17] VGND VGND VPWR VPWR pp.column[0].fa.ci sky130_fd_sc_hd__xor2_1
X_272_ sync[18] prev[18] VGND VGND VPWR VPWR pp.column[1].fa.a sky130_fd_sc_hd__xor2_1
X_273_ sync[19] prev[19] VGND VGND VPWR VPWR pp.column[1].fa.b sky130_fd_sc_hd__xor2_1
X_274_ sync[20] prev[20] VGND VGND VPWR VPWR pp.column[1].fa.ci sky130_fd_sc_hd__xor2_1
X_275_ sync[21] prev[21] VGND VGND VPWR VPWR pp.column[2].fa.a sky130_fd_sc_hd__xor2_1
X_276_ sync[22] prev[22] VGND VGND VPWR VPWR pp.column[2].fa.b sky130_fd_sc_hd__xor2_1
X_277_ sync[23] prev[23] VGND VGND VPWR VPWR pp.column[2].fa.ci sky130_fd_sc_hd__xor2_1
X_278_ sync[24] prev[24] VGND VGND VPWR VPWR pp.column[3].fa.a sky130_fd_sc_hd__xor2_1
X_279_ sync[25] prev[25] VGND VGND VPWR VPWR pp.column[3].fa.b sky130_fd_sc_hd__xor2_1
X_280_ sync[26] prev[26] VGND VGND VPWR VPWR pp.column[3].fa.ci sky130_fd_sc_hd__xor2_1
X_281_ sync[27] prev[27] VGND VGND VPWR VPWR pp.column[4].fa.a sky130_fd_sc_hd__xor2_1
X_282_ sync[28] prev[28] VGND VGND VPWR VPWR pp.column[4].fa.b sky130_fd_sc_hd__xor2_1
X_283_ sync[29] prev[29] VGND VGND VPWR VPWR pp.column[4].fa.ci sky130_fd_sc_hd__xor2_1
X_284_ net29 _071_ VGND VGND VPWR VPWR second sky130_fd_sc_hd__xnor2_1
X_285_ vn.count[0] vn.count[1] VGND VGND VPWR VPWR _107_ sky130_fd_sc_hd__nand2_1
X_286_ vn.count[0] vn.count[1] VGND VGND VPWR VPWR _112_[1] sky130_fd_sc_hd__xor2_1
X_287_ vn.count[2] _107_ VGND VGND VPWR VPWR _112_[2] sky130_fd_sc_hd__xnor2_1
X_288_ vn.count[0] vn.count[1] vn.count[3] vn.count[2] VGND VGND VPWR VPWR _108_ sky130_fd_sc_hd__nand4_2
X_289_ vn.count[0] vn.count[1] vn.count[2] vn.count[3] VGND VGND VPWR VPWR _109_ sky130_fd_sc_hd__a31oi_1
X_290_ _108_ _109_ VGND VGND VPWR VPWR _112_[3] sky130_fd_sc_hd__lpflow_isobufsrc_1
X_291_ vn.count[4] _108_ VGND VGND VPWR VPWR _110_ sky130_fd_sc_hd__lpflow_isobufsrc_1
X_292_ vn.count[4] _108_ VGND VGND VPWR VPWR _112_[4] sky130_fd_sc_hd__xnor2_1
X_293_ vn.divided _110_ VGND VGND VPWR VPWR _112_[5] sky130_fd_sc_hd__xor2_1
X_294_ clknet_4_7_0_clk _004_ run_n VGND VGND VPWR VPWR wrap_err sky130_fd_sc_hd__dfrtp_4
X_295_ clknet_4_15_0_clk _001_ run_n VGND VGND VPWR VPWR cs_n sky130_fd_sc_hd__dfstp_1
X_296_ clknet_4_15_0_clk _003_ run_n VGND VGND VPWR VPWR sclk sky130_fd_sc_hd__dfrtp_2
X_297_ clknet_4_15_0_clk _005_ run_n VGND VGND VPWR VPWR sdo sky130_fd_sc_hd__dfrtp_2
X_298_ clknet_4_5_0_clk _006_ run_n VGND VGND VPWR VPWR borrow1 sky130_fd_sc_hd__dfrtp_1
X_299_ clknet_2_3__leaf_g_delay.gclk delay1[1] VGND VGND VPWR VPWR delay1[0] sky130_fd_sc_hd__dfxtp_1
X_300_ clknet_2_3__leaf_g_delay.gclk delay1[2] VGND VGND VPWR VPWR delay1[1] sky130_fd_sc_hd__dfxtp_1
X_301_ clknet_2_3__leaf_g_delay.gclk delay1[3] VGND VGND VPWR VPWR delay1[2] sky130_fd_sc_hd__dfxtp_1
X_302_ clknet_2_3__leaf_g_delay.gclk delay1[4] VGND VGND VPWR VPWR delay1[3] sky130_fd_sc_hd__dfxtp_1
X_303_ clknet_2_1__leaf_g_delay.gclk delay1[5] VGND VGND VPWR VPWR delay1[4] sky130_fd_sc_hd__dfxtp_1
X_304_ clknet_2_3__leaf_g_delay.gclk delay1[6] VGND VGND VPWR VPWR delay1[5] sky130_fd_sc_hd__dfxtp_1
X_305_ clknet_2_3__leaf_g_delay.gclk delay1[7] VGND VGND VPWR VPWR delay1[6] sky130_fd_sc_hd__dfxtp_1
X_306_ clknet_2_1__leaf_g_delay.gclk delay1[8] VGND VGND VPWR VPWR delay1[7] sky130_fd_sc_hd__dfxtp_1
X_307_ clknet_2_1__leaf_g_delay.gclk delay1[9] VGND VGND VPWR VPWR delay1[8] sky130_fd_sc_hd__dfxtp_1
X_308_ clknet_2_1__leaf_g_delay.gclk delay1[10] VGND VGND VPWR VPWR delay1[9] sky130_fd_sc_hd__dfxtp_1
X_309_ clknet_2_1__leaf_g_delay.gclk delay1[11] VGND VGND VPWR VPWR delay1[10] sky130_fd_sc_hd__dfxtp_1
X_310_ clknet_2_1__leaf_g_delay.gclk delay1[12] VGND VGND VPWR VPWR delay1[11] sky130_fd_sc_hd__dfxtp_1
X_311_ clknet_2_3__leaf_g_delay.gclk delay1[13] VGND VGND VPWR VPWR delay1[12] sky130_fd_sc_hd__dfxtp_1
X_312_ clknet_2_1__leaf_g_delay.gclk delay1[14] VGND VGND VPWR VPWR delay1[13] sky130_fd_sc_hd__dfxtp_1
X_313_ clknet_2_1__leaf_g_delay.gclk delay1[15] VGND VGND VPWR VPWR delay1[14] sky130_fd_sc_hd__dfxtp_1
X_314_ clknet_2_1__leaf_g_delay.gclk delay1[16] VGND VGND VPWR VPWR delay1[15] sky130_fd_sc_hd__dfxtp_1
X_315_ clknet_2_1__leaf_g_delay.gclk delay1[17] VGND VGND VPWR VPWR delay1[16] sky130_fd_sc_hd__dfxtp_1
X_316_ clknet_2_0__leaf_g_delay.gclk delay1[18] VGND VGND VPWR VPWR delay1[17] sky130_fd_sc_hd__dfxtp_1
X_317_ clknet_2_1__leaf_g_delay.gclk delay1[19] VGND VGND VPWR VPWR delay1[18] sky130_fd_sc_hd__dfxtp_1
X_318_ clknet_2_1__leaf_g_delay.gclk delay1[20] VGND VGND VPWR VPWR delay1[19] sky130_fd_sc_hd__dfxtp_1
X_319_ clknet_2_3__leaf_g_delay.gclk a VGND VGND VPWR VPWR delay1[20] sky130_fd_sc_hd__dfxtp_1
X_320_ clknet_2_2__leaf_g_delay.gclk delay2[1] VGND VGND VPWR VPWR delay2[0] sky130_fd_sc_hd__dfxtp_1
X_321_ clknet_2_2__leaf_g_delay.gclk delay2[2] VGND VGND VPWR VPWR delay2[1] sky130_fd_sc_hd__dfxtp_1
X_322_ clknet_2_2__leaf_g_delay.gclk delay2[3] VGND VGND VPWR VPWR delay2[2] sky130_fd_sc_hd__dfxtp_1
X_323_ clknet_2_2__leaf_g_delay.gclk delay2[4] VGND VGND VPWR VPWR delay2[3] sky130_fd_sc_hd__dfxtp_1
X_324_ clknet_2_2__leaf_g_delay.gclk delay2[5] VGND VGND VPWR VPWR delay2[4] sky130_fd_sc_hd__dfxtp_1
X_325_ clknet_2_2__leaf_g_delay.gclk delay2[6] VGND VGND VPWR VPWR delay2[5] sky130_fd_sc_hd__dfxtp_1
X_326_ clknet_2_2__leaf_g_delay.gclk delay2[7] VGND VGND VPWR VPWR delay2[6] sky130_fd_sc_hd__dfxtp_1
X_327_ clknet_2_0__leaf_g_delay.gclk delay2[8] VGND VGND VPWR VPWR delay2[7] sky130_fd_sc_hd__dfxtp_1
X_328_ clknet_2_2__leaf_g_delay.gclk delay2[9] VGND VGND VPWR VPWR delay2[8] sky130_fd_sc_hd__dfxtp_1
X_329_ clknet_2_0__leaf_g_delay.gclk delay2[10] VGND VGND VPWR VPWR delay2[9] sky130_fd_sc_hd__dfxtp_1
X_330_ clknet_2_0__leaf_g_delay.gclk delay2[11] VGND VGND VPWR VPWR delay2[10] sky130_fd_sc_hd__dfxtp_1
X_331_ clknet_2_0__leaf_g_delay.gclk delay2[12] VGND VGND VPWR VPWR delay2[11] sky130_fd_sc_hd__dfxtp_1
X_332_ clknet_2_0__leaf_g_delay.gclk delay2[13] VGND VGND VPWR VPWR delay2[12] sky130_fd_sc_hd__dfxtp_1
X_333_ clknet_2_0__leaf_g_delay.gclk delay2[14] VGND VGND VPWR VPWR delay2[13] sky130_fd_sc_hd__dfxtp_1
X_334_ clknet_2_0__leaf_g_delay.gclk delay2[15] VGND VGND VPWR VPWR delay2[14] sky130_fd_sc_hd__dfxtp_1
X_335_ clknet_2_0__leaf_g_delay.gclk delay2[16] VGND VGND VPWR VPWR delay2[15] sky130_fd_sc_hd__dfxtp_1
X_336_ clknet_2_2__leaf_g_delay.gclk delay2[17] VGND VGND VPWR VPWR delay2[16] sky130_fd_sc_hd__dfxtp_1
X_337_ clknet_2_2__leaf_g_delay.gclk delay2[18] VGND VGND VPWR VPWR delay2[17] sky130_fd_sc_hd__dfxtp_1
X_338_ clknet_2_3__leaf_g_delay.gclk delay2[19] VGND VGND VPWR VPWR delay2[18] sky130_fd_sc_hd__dfxtp_1
X_339_ clknet_2_2__leaf_g_delay.gclk delay2[20] VGND VGND VPWR VPWR delay2[19] sky130_fd_sc_hd__dfxtp_1
X_340_ clknet_2_0__leaf_g_delay.gclk first VGND VGND VPWR VPWR delay2[20] sky130_fd_sc_hd__dfxtp_1
X_341_ clknet_4_5_0_clk _007_ run_n VGND VGND VPWR VPWR borrow2 sky130_fd_sc_hd__dfrtp_1
X_342_ clknet_4_13_0_clk _008_ run_n VGND VGND VPWR VPWR history_valid sky130_fd_sc_hd__dfrtp_1
X_343_ clknet_4_13_0_clk _009_ run_n VGND VGND VPWR VPWR rate sky130_fd_sc_hd__dfrtp_4
X_344_ clknet_4_15_0_clk _002_[0] run_n VGND VGND VPWR VPWR phase[0] sky130_fd_sc_hd__dfrtp_4
X_345_ clknet_4_15_0_clk _002_[1] run_n VGND VGND VPWR VPWR phase[1] sky130_fd_sc_hd__dfrtp_4
X_346_ clknet_4_15_0_clk _002_[2] run_n VGND VGND VPWR VPWR phase[2] sky130_fd_sc_hd__dfrtp_4
X_347_ clknet_4_15_0_clk _002_[3] run_n VGND VGND VPWR VPWR phase[3] sky130_fd_sc_hd__dfrtp_4
X_348_ clknet_4_15_0_clk _002_[4] run_n VGND VGND VPWR VPWR phase[4] sky130_fd_sc_hd__dfrtp_4
X_349_ clknet_4_15_0_clk _002_[5] run_n VGND VGND VPWR VPWR phase[5] sky130_fd_sc_hd__dfrtp_4
X_350_ clknet_4_15_0_clk _002_[6] run_n VGND VGND VPWR VPWR phase[6] sky130_fd_sc_hd__dfrtp_2
X_351_ clknet_4_13_0_clk _002_[7] run_n VGND VGND VPWR VPWR phase[7] sky130_fd_sc_hd__dfrtp_2
X_352_ clknet_4_7_0_clk add1.bit_add[0].fa.sum net3 VGND VGND VPWR VPWR add1.bit_add[0].fa.a sky130_fd_sc_hd__dfrtp_1
X_353_ clknet_4_7_0_clk add1.bit_add[1].fa.sum net3 VGND VGND VPWR VPWR add1.bit_add[1].fa.a sky130_fd_sc_hd__dfrtp_1
X_354_ clknet_4_5_0_clk add1.bit_add[2].fa.sum net3 VGND VGND VPWR VPWR add1.bit_add[2].fa.a sky130_fd_sc_hd__dfrtp_1
X_355_ clknet_4_13_0_clk add1.bit_add[3].fa.sum net3 VGND VGND VPWR VPWR add1.bit_add[3].fa.a sky130_fd_sc_hd__dfrtp_1
X_356_ clknet_4_12_0_clk add1.bit_add[4].fa.sum cic_n VGND VGND VPWR VPWR add1.bit_add[4].fa.a sky130_fd_sc_hd__dfrtp_1
X_357_ clknet_4_15_0_clk add1.bit_add[5].fa.sum cic_n VGND VGND VPWR VPWR add1.bit_add[5].fa.a sky130_fd_sc_hd__dfrtp_1
X_358_ clknet_4_14_0_clk add1.bit_add[6].fa.sum net2 VGND VGND VPWR VPWR add1.bit_add[6].fa.a sky130_fd_sc_hd__dfrtp_1
X_359_ clknet_4_14_0_clk add1.bit_add[7].fa.sum net2 VGND VGND VPWR VPWR add1.bit_add[7].fa.a sky130_fd_sc_hd__dfrtp_1
X_360_ clknet_4_14_0_clk add1.bit_add[8].fa.sum net2 VGND VGND VPWR VPWR add1.bit_add[8].fa.a sky130_fd_sc_hd__dfrtp_1
X_361_ clknet_4_14_0_clk add1.bit_add[9].fa.sum net2 VGND VGND VPWR VPWR add1.bit_add[9].fa.a sky130_fd_sc_hd__dfrtp_1
X_362_ clknet_4_11_0_clk add1.bit_add[10].fa.sum net2 VGND VGND VPWR VPWR add1.bit_add[10].fa.a sky130_fd_sc_hd__dfrtp_1
X_363_ clknet_4_11_0_clk add1.bit_add[11].fa.sum net2 VGND VGND VPWR VPWR add1.bit_add[11].fa.a sky130_fd_sc_hd__dfrtp_1
X_364_ clknet_4_11_0_clk add1.bit_add[12].fa.sum net2 VGND VGND VPWR VPWR add1.bit_add[12].fa.a sky130_fd_sc_hd__dfrtp_1
X_365_ clknet_4_9_0_clk add1.bit_add[13].fa.sum net2 VGND VGND VPWR VPWR add1.bit_add[13].fa.a sky130_fd_sc_hd__dfrtp_1
X_366_ clknet_4_9_0_clk add1.bit_add[14].fa.sum cic_n VGND VGND VPWR VPWR add1.bit_add[14].fa.a sky130_fd_sc_hd__dfrtp_1
X_367_ clknet_4_9_0_clk add1.bit_add[15].fa.sum cic_n VGND VGND VPWR VPWR add1.bit_add[15].fa.a sky130_fd_sc_hd__dfrtp_1
X_368_ clknet_4_6_0_clk add1.bit_add[16].fa.sum cic_n VGND VGND VPWR VPWR add1.bit_add[16].fa.a sky130_fd_sc_hd__dfrtp_1
X_369_ clknet_4_6_0_clk add1.bit_add[17].fa.sum net3 VGND VGND VPWR VPWR add1.bit_add[17].fa.a sky130_fd_sc_hd__dfrtp_1
X_370_ clknet_4_6_0_clk add1.bit_add[18].fa.sum net3 VGND VGND VPWR VPWR add1.bit_add[18].fa.a sky130_fd_sc_hd__dfrtp_1
X_371_ clknet_4_4_0_clk add1.bit_add[19].fa.sum net3 VGND VGND VPWR VPWR add1.bit_add[19].fa.a sky130_fd_sc_hd__dfrtp_1
X_372_ clknet_4_7_0_clk add1.bit_add[20].fa.sum net3 VGND VGND VPWR VPWR add1.bit_add[20].fa.a sky130_fd_sc_hd__dfrtp_1
X_373_ clknet_4_13_0_clk add2.bit_add[0].fa.sum net3 VGND VGND VPWR VPWR add2.bit_add[0].fa.a sky130_fd_sc_hd__dfrtp_1
X_374_ clknet_4_7_0_clk add2.bit_add[1].fa.sum net3 VGND VGND VPWR VPWR add2.bit_add[1].fa.a sky130_fd_sc_hd__dfrtp_1
X_375_ clknet_4_4_0_clk add2.bit_add[2].fa.sum net3 VGND VGND VPWR VPWR add2.bit_add[2].fa.a sky130_fd_sc_hd__dfrtp_1
X_376_ clknet_4_12_0_clk add2.bit_add[3].fa.sum cic_n VGND VGND VPWR VPWR add2.bit_add[3].fa.a sky130_fd_sc_hd__dfrtp_1
X_377_ clknet_4_12_0_clk add2.bit_add[4].fa.sum cic_n VGND VGND VPWR VPWR add2.bit_add[4].fa.a sky130_fd_sc_hd__dfrtp_1
X_378_ clknet_4_15_0_clk add2.bit_add[5].fa.sum net2 VGND VGND VPWR VPWR add2.bit_add[5].fa.a sky130_fd_sc_hd__dfrtp_1
X_379_ clknet_4_15_0_clk add2.bit_add[6].fa.sum net2 VGND VGND VPWR VPWR add2.bit_add[6].fa.a sky130_fd_sc_hd__dfrtp_1
X_380_ clknet_4_14_0_clk add2.bit_add[7].fa.sum net2 VGND VGND VPWR VPWR add2.bit_add[7].fa.a sky130_fd_sc_hd__dfrtp_1
X_381_ clknet_4_14_0_clk add2.bit_add[8].fa.sum net2 VGND VGND VPWR VPWR add2.bit_add[8].fa.a sky130_fd_sc_hd__dfrtp_1
X_382_ clknet_4_14_0_clk add2.bit_add[9].fa.sum net2 VGND VGND VPWR VPWR add2.bit_add[9].fa.a sky130_fd_sc_hd__dfrtp_1
X_383_ clknet_4_14_0_clk add2.bit_add[10].fa.sum net2 VGND VGND VPWR VPWR add2.bit_add[10].fa.a sky130_fd_sc_hd__dfrtp_1
X_384_ clknet_4_14_0_clk add2.bit_add[11].fa.sum net2 VGND VGND VPWR VPWR add2.bit_add[11].fa.a sky130_fd_sc_hd__dfrtp_1
X_385_ clknet_4_14_0_clk add2.bit_add[12].fa.sum net2 VGND VGND VPWR VPWR add2.bit_add[12].fa.a sky130_fd_sc_hd__dfrtp_1
X_386_ clknet_4_12_0_clk add2.bit_add[13].fa.sum net2 VGND VGND VPWR VPWR add2.bit_add[13].fa.a sky130_fd_sc_hd__dfrtp_1
X_387_ clknet_4_12_0_clk add2.bit_add[14].fa.sum net2 VGND VGND VPWR VPWR add2.bit_add[14].fa.a sky130_fd_sc_hd__dfrtp_1
X_388_ clknet_4_12_0_clk add2.bit_add[15].fa.sum cic_n VGND VGND VPWR VPWR add2.bit_add[15].fa.a sky130_fd_sc_hd__dfrtp_1
X_389_ clknet_4_12_0_clk add2.bit_add[16].fa.sum cic_n VGND VGND VPWR VPWR add2.bit_add[16].fa.a sky130_fd_sc_hd__dfrtp_1
X_390_ clknet_4_7_0_clk add2.bit_add[17].fa.sum net3 VGND VGND VPWR VPWR add2.bit_add[17].fa.a sky130_fd_sc_hd__dfrtp_1
X_391_ clknet_4_6_0_clk add2.bit_add[18].fa.sum net3 VGND VGND VPWR VPWR add2.bit_add[18].fa.a sky130_fd_sc_hd__dfrtp_1
X_392_ clknet_4_6_0_clk add2.bit_add[19].fa.sum net3 VGND VGND VPWR VPWR add2.bit_add[19].fa.a sky130_fd_sc_hd__dfrtp_1
X_393_ clknet_4_4_0_clk add2.bit_add[20].fa.sum net3 VGND VGND VPWR VPWR add2.bit_add[20].fa.a sky130_fd_sc_hd__dfrtp_1
X_394_ clknet_4_13_0_clk _000_ run_n VGND VGND VPWR VPWR cic_n sky130_fd_sc_hd__dfrtn_1
X_395_ clknet_4_13_0_clk _010_ run_n VGND VGND VPWR VPWR sampled sky130_fd_sc_hd__dfrtp_4
X_396_ clknet_4_5_0_clk net6 run_n VGND VGND VPWR VPWR valid[0] sky130_fd_sc_hd__dfrtp_1
X_397_ clknet_4_4_0_clk valid[0] run_n VGND VGND VPWR VPWR valid[1] sky130_fd_sc_hd__dfrtp_1
X_398_ clknet_4_5_0_clk valid[1] run_n VGND VGND VPWR VPWR valid[2] sky130_fd_sc_hd__dfrtp_1
X_399_ clknet_4_5_0_clk valid[2] run_n VGND VGND VPWR VPWR valid[3] sky130_fd_sc_hd__dfrtp_2
X_400_ clknet_4_2_0_clk clknet_1_1__leaf_tap_n[0] VGND VGND VPWR VPWR meta[0] sky130_fd_sc_hd__dfxtp_1
X_401_ clknet_4_8_0_clk tap_n[1] VGND VGND VPWR VPWR meta[1] sky130_fd_sc_hd__dfxtp_1
X_402_ clknet_4_8_0_clk tap_n[2] VGND VGND VPWR VPWR meta[2] sky130_fd_sc_hd__dfxtp_1
X_403_ clknet_4_8_0_clk tap_n[3] VGND VGND VPWR VPWR meta[3] sky130_fd_sc_hd__dfxtp_1
X_404_ clknet_4_8_0_clk tap_n[4] VGND VGND VPWR VPWR meta[4] sky130_fd_sc_hd__dfxtp_1
X_405_ clknet_4_8_0_clk tap_n[5] VGND VGND VPWR VPWR meta[5] sky130_fd_sc_hd__dfxtp_1
X_406_ clknet_4_8_0_clk tap_n[6] VGND VGND VPWR VPWR meta[6] sky130_fd_sc_hd__dfxtp_1
X_407_ clknet_4_10_0_clk tap_n[7] VGND VGND VPWR VPWR meta[7] sky130_fd_sc_hd__dfxtp_1
X_408_ clknet_4_10_0_clk tap_n[8] VGND VGND VPWR VPWR meta[8] sky130_fd_sc_hd__dfxtp_1
X_409_ clknet_4_10_0_clk tap_n[9] VGND VGND VPWR VPWR meta[9] sky130_fd_sc_hd__dfxtp_1
X_410_ clknet_4_11_0_clk tap_n[10] VGND VGND VPWR VPWR meta[10] sky130_fd_sc_hd__dfxtp_1
X_411_ clknet_4_11_0_clk tap_n[11] VGND VGND VPWR VPWR meta[11] sky130_fd_sc_hd__dfxtp_1
X_412_ clknet_4_11_0_clk tap_n[12] VGND VGND VPWR VPWR meta[12] sky130_fd_sc_hd__dfxtp_1
X_413_ clknet_4_11_0_clk tap_n[13] VGND VGND VPWR VPWR meta[13] sky130_fd_sc_hd__dfxtp_1
X_414_ clknet_4_11_0_clk tap_n[14] VGND VGND VPWR VPWR meta[14] sky130_fd_sc_hd__dfxtp_1
X_415_ clknet_4_0_0_clk clknet_1_0__leaf_tap_p[0] VGND VGND VPWR VPWR meta[15] sky130_fd_sc_hd__dfxtp_1
X_416_ clknet_4_1_0_clk tap_p[1] VGND VGND VPWR VPWR meta[16] sky130_fd_sc_hd__dfxtp_1
X_417_ clknet_4_1_0_clk tap_p[2] VGND VGND VPWR VPWR meta[17] sky130_fd_sc_hd__dfxtp_1
X_418_ clknet_4_1_0_clk tap_p[3] VGND VGND VPWR VPWR meta[18] sky130_fd_sc_hd__dfxtp_1
X_419_ clknet_4_1_0_clk tap_p[4] VGND VGND VPWR VPWR meta[19] sky130_fd_sc_hd__dfxtp_1
X_420_ clknet_4_1_0_clk tap_p[5] VGND VGND VPWR VPWR meta[20] sky130_fd_sc_hd__dfxtp_1
X_421_ clknet_4_1_0_clk tap_p[6] VGND VGND VPWR VPWR meta[21] sky130_fd_sc_hd__dfxtp_1
X_422_ clknet_4_0_0_clk tap_p[7] VGND VGND VPWR VPWR meta[22] sky130_fd_sc_hd__dfxtp_1
X_423_ clknet_4_1_0_clk tap_p[8] VGND VGND VPWR VPWR meta[23] sky130_fd_sc_hd__dfxtp_1
X_424_ clknet_4_1_0_clk tap_p[9] VGND VGND VPWR VPWR meta[24] sky130_fd_sc_hd__dfxtp_1
X_425_ clknet_4_3_0_clk tap_p[10] VGND VGND VPWR VPWR meta[25] sky130_fd_sc_hd__dfxtp_1
X_426_ clknet_4_3_0_clk tap_p[11] VGND VGND VPWR VPWR meta[26] sky130_fd_sc_hd__dfxtp_1
X_427_ clknet_4_3_0_clk tap_p[12] VGND VGND VPWR VPWR meta[27] sky130_fd_sc_hd__dfxtp_1
X_428_ clknet_4_2_0_clk tap_p[13] VGND VGND VPWR VPWR meta[28] sky130_fd_sc_hd__dfxtp_1
X_429_ clknet_4_3_0_clk tap_p[14] VGND VGND VPWR VPWR meta[29] sky130_fd_sc_hd__dfxtp_1
X_430_ clknet_4_9_0_clk meta[0] VGND VGND VPWR VPWR sync[0] sky130_fd_sc_hd__dfxtp_1
X_431_ clknet_4_9_0_clk meta[1] VGND VGND VPWR VPWR sync[1] sky130_fd_sc_hd__dfxtp_1
X_432_ clknet_4_9_0_clk meta[2] VGND VGND VPWR VPWR sync[2] sky130_fd_sc_hd__dfxtp_1
X_433_ clknet_4_8_0_clk meta[3] VGND VGND VPWR VPWR sync[3] sky130_fd_sc_hd__dfxtp_1
X_434_ clknet_4_8_0_clk meta[4] VGND VGND VPWR VPWR sync[4] sky130_fd_sc_hd__dfxtp_1
X_435_ clknet_4_10_0_clk meta[5] VGND VGND VPWR VPWR sync[5] sky130_fd_sc_hd__dfxtp_1
X_436_ clknet_4_10_0_clk meta[6] VGND VGND VPWR VPWR sync[6] sky130_fd_sc_hd__dfxtp_1
X_437_ clknet_4_10_0_clk meta[7] VGND VGND VPWR VPWR sync[7] sky130_fd_sc_hd__dfxtp_1
X_438_ clknet_4_11_0_clk meta[8] VGND VGND VPWR VPWR sync[8] sky130_fd_sc_hd__dfxtp_1
X_439_ clknet_4_11_0_clk meta[9] VGND VGND VPWR VPWR sync[9] sky130_fd_sc_hd__dfxtp_1
X_440_ clknet_4_10_0_clk meta[10] VGND VGND VPWR VPWR sync[10] sky130_fd_sc_hd__dfxtp_1
X_441_ clknet_4_10_0_clk meta[11] VGND VGND VPWR VPWR sync[11] sky130_fd_sc_hd__dfxtp_1
X_442_ clknet_4_10_0_clk meta[12] VGND VGND VPWR VPWR sync[12] sky130_fd_sc_hd__dfxtp_1
X_443_ clknet_4_11_0_clk meta[13] VGND VGND VPWR VPWR sync[13] sky130_fd_sc_hd__dfxtp_1
X_444_ clknet_4_10_0_clk meta[14] VGND VGND VPWR VPWR sync[14] sky130_fd_sc_hd__dfxtp_1
X_445_ clknet_4_0_0_clk meta[15] VGND VGND VPWR VPWR sync[15] sky130_fd_sc_hd__dfxtp_1
X_446_ clknet_4_0_0_clk meta[16] VGND VGND VPWR VPWR sync[16] sky130_fd_sc_hd__dfxtp_1
X_447_ clknet_4_0_0_clk meta[17] VGND VGND VPWR VPWR sync[17] sky130_fd_sc_hd__dfxtp_1
X_448_ clknet_4_1_0_clk meta[18] VGND VGND VPWR VPWR sync[18] sky130_fd_sc_hd__dfxtp_1
X_449_ clknet_4_0_0_clk meta[19] VGND VGND VPWR VPWR sync[19] sky130_fd_sc_hd__dfxtp_1
X_450_ clknet_4_1_0_clk meta[20] VGND VGND VPWR VPWR sync[20] sky130_fd_sc_hd__dfxtp_1
X_451_ clknet_4_1_0_clk meta[21] VGND VGND VPWR VPWR sync[21] sky130_fd_sc_hd__dfxtp_1
X_452_ clknet_4_1_0_clk meta[22] VGND VGND VPWR VPWR sync[22] sky130_fd_sc_hd__dfxtp_1
X_453_ clknet_4_1_0_clk meta[23] VGND VGND VPWR VPWR sync[23] sky130_fd_sc_hd__dfxtp_1
X_454_ clknet_4_3_0_clk meta[24] VGND VGND VPWR VPWR sync[24] sky130_fd_sc_hd__dfxtp_1
X_455_ clknet_4_3_0_clk meta[25] VGND VGND VPWR VPWR sync[25] sky130_fd_sc_hd__dfxtp_1
X_456_ clknet_4_2_0_clk meta[26] VGND VGND VPWR VPWR sync[26] sky130_fd_sc_hd__dfxtp_1
X_457_ clknet_4_3_0_clk meta[27] VGND VGND VPWR VPWR sync[27] sky130_fd_sc_hd__dfxtp_1
X_458_ clknet_4_3_0_clk meta[28] VGND VGND VPWR VPWR sync[28] sky130_fd_sc_hd__dfxtp_1
X_459_ clknet_4_2_0_clk meta[29] VGND VGND VPWR VPWR sync[29] sky130_fd_sc_hd__dfxtp_1
X_460_ clknet_4_9_0_clk sync[0] VGND VGND VPWR VPWR prev[0] sky130_fd_sc_hd__dfxtp_1
X_461_ clknet_4_9_0_clk sync[1] VGND VGND VPWR VPWR prev[1] sky130_fd_sc_hd__dfxtp_1
X_462_ clknet_4_9_0_clk sync[2] VGND VGND VPWR VPWR prev[2] sky130_fd_sc_hd__dfxtp_1
X_463_ clknet_4_8_0_clk sync[3] VGND VGND VPWR VPWR prev[3] sky130_fd_sc_hd__dfxtp_1
X_464_ clknet_4_8_0_clk sync[4] VGND VGND VPWR VPWR prev[4] sky130_fd_sc_hd__dfxtp_1
X_465_ clknet_4_10_0_clk sync[5] VGND VGND VPWR VPWR prev[5] sky130_fd_sc_hd__dfxtp_1
X_466_ clknet_4_11_0_clk sync[6] VGND VGND VPWR VPWR prev[6] sky130_fd_sc_hd__dfxtp_1
X_467_ clknet_4_11_0_clk sync[7] VGND VGND VPWR VPWR prev[7] sky130_fd_sc_hd__dfxtp_1
X_468_ clknet_4_11_0_clk sync[8] VGND VGND VPWR VPWR prev[8] sky130_fd_sc_hd__dfxtp_1
X_469_ clknet_4_11_0_clk sync[9] VGND VGND VPWR VPWR prev[9] sky130_fd_sc_hd__dfxtp_1
X_470_ clknet_4_11_0_clk sync[10] VGND VGND VPWR VPWR prev[10] sky130_fd_sc_hd__dfxtp_1
X_471_ clknet_4_11_0_clk sync[11] VGND VGND VPWR VPWR prev[11] sky130_fd_sc_hd__dfxtp_1
X_472_ clknet_4_10_0_clk sync[12] VGND VGND VPWR VPWR prev[12] sky130_fd_sc_hd__dfxtp_1
X_473_ clknet_4_11_0_clk sync[13] VGND VGND VPWR VPWR prev[13] sky130_fd_sc_hd__dfxtp_1
X_474_ clknet_4_10_0_clk sync[14] VGND VGND VPWR VPWR prev[14] sky130_fd_sc_hd__dfxtp_1
X_475_ clknet_4_0_0_clk sync[15] VGND VGND VPWR VPWR prev[15] sky130_fd_sc_hd__dfxtp_1
X_476_ clknet_4_1_0_clk sync[16] VGND VGND VPWR VPWR prev[16] sky130_fd_sc_hd__dfxtp_1
X_477_ clknet_4_0_0_clk sync[17] VGND VGND VPWR VPWR prev[17] sky130_fd_sc_hd__dfxtp_1
X_478_ clknet_4_0_0_clk sync[18] VGND VGND VPWR VPWR prev[18] sky130_fd_sc_hd__dfxtp_1
X_479_ clknet_4_1_0_clk sync[19] VGND VGND VPWR VPWR prev[19] sky130_fd_sc_hd__dfxtp_1
X_480_ clknet_4_0_0_clk sync[20] VGND VGND VPWR VPWR prev[20] sky130_fd_sc_hd__dfxtp_1
X_481_ clknet_4_0_0_clk sync[21] VGND VGND VPWR VPWR prev[21] sky130_fd_sc_hd__dfxtp_1
X_482_ clknet_4_3_0_clk sync[22] VGND VGND VPWR VPWR prev[22] sky130_fd_sc_hd__dfxtp_1
X_483_ clknet_4_3_0_clk sync[23] VGND VGND VPWR VPWR prev[23] sky130_fd_sc_hd__dfxtp_1
X_484_ clknet_4_2_0_clk sync[24] VGND VGND VPWR VPWR prev[24] sky130_fd_sc_hd__dfxtp_1
X_485_ clknet_4_6_0_clk sync[25] VGND VGND VPWR VPWR prev[25] sky130_fd_sc_hd__dfxtp_1
X_486_ clknet_4_2_0_clk sync[26] VGND VGND VPWR VPWR prev[26] sky130_fd_sc_hd__dfxtp_1
X_487_ clknet_4_8_0_clk sync[27] VGND VGND VPWR VPWR prev[27] sky130_fd_sc_hd__dfxtp_1
X_488_ clknet_4_2_0_clk sync[28] VGND VGND VPWR VPWR prev[28] sky130_fd_sc_hd__dfxtp_1
X_489_ clknet_4_8_0_clk sync[29] VGND VGND VPWR VPWR prev[29] sky130_fd_sc_hd__dfxtp_1
X_490_ clknet_4_4_0_clk err_clr run_n VGND VGND VPWR VPWR clear_sync[0] sky130_fd_sc_hd__dfrtp_1
X_491_ clknet_4_5_0_clk clear_sync[0] run_n VGND VGND VPWR VPWR clear_sync[1] sky130_fd_sc_hd__dfrtp_1
X_492_ clknet_4_13_0_clk osr_sel run_n VGND VGND VPWR VPWR rate_sync[0] sky130_fd_sc_hd__dfrtp_1
X_493_ clknet_4_13_0_clk rate_sync[0] run_n VGND VGND VPWR VPWR rate_sync[1] sky130_fd_sc_hd__dfrtp_1
X_494_ clknet_4_4_0_clk net7 rst_n VGND VGND VPWR VPWR reset_sync[0] sky130_fd_sc_hd__dfrtp_1
X_495_ clknet_4_4_0_clk reset_sync[0] rst_n VGND VGND VPWR VPWR run_n sky130_fd_sc_hd__dfrtp_4
X_496_ clknet_1_0__leaf_vp.cg.gclk _113_[0] rst_n VGND VGND VPWR VPWR vp.count[0] sky130_fd_sc_hd__dfrtp_2
X_497_ clknet_1_0__leaf_vp.cg.gclk _114_[1] rst_n VGND VGND VPWR VPWR vp.count[1] sky130_fd_sc_hd__dfrtp_2
X_498_ clknet_1_0__leaf_vp.cg.gclk _114_[2] rst_n VGND VGND VPWR VPWR vp.count[2] sky130_fd_sc_hd__dfrtp_1
X_499_ clknet_1_1__leaf_vp.cg.gclk _114_[3] rst_n VGND VGND VPWR VPWR vp.count[3] sky130_fd_sc_hd__dfrtp_1
X_500_ clknet_1_1__leaf_vp.cg.gclk _114_[4] rst_n VGND VGND VPWR VPWR vp.count[4] sky130_fd_sc_hd__dfrtp_1
X_501_ clknet_1_1__leaf_vp.cg.gclk _114_[5] rst_n VGND VGND VPWR VPWR vp.divided sky130_fd_sc_hd__dfrtp_1
X_502_ clknet_1_0__leaf_vn.cg.gclk _111_[0] rst_n VGND VGND VPWR VPWR vn.count[0] sky130_fd_sc_hd__dfrtp_2
X_503_ clknet_1_1__leaf_vn.cg.gclk _112_[1] rst_n VGND VGND VPWR VPWR vn.count[1] sky130_fd_sc_hd__dfrtp_2
X_504_ clknet_1_1__leaf_vn.cg.gclk _112_[2] rst_n VGND VGND VPWR VPWR vn.count[2] sky130_fd_sc_hd__dfrtp_1
X_505_ clknet_1_1__leaf_vn.cg.gclk _112_[3] rst_n VGND VGND VPWR VPWR vn.count[3] sky130_fd_sc_hd__dfrtp_1
X_506_ clknet_1_0__leaf_vn.cg.gclk _112_[4] rst_n VGND VGND VPWR VPWR vn.count[4] sky130_fd_sc_hd__dfrtp_1
X_507_ clknet_1_0__leaf_vn.cg.gclk _112_[5] rst_n VGND VGND VPWR VPWR vn.divided sky130_fd_sc_hd__dfrtp_1
Xadd1.bit_add[0].fa.fa add1.bit_add[0].fa.a add1.bit_add[0].fa.b net4 VGND VGND VPWR VPWR add1.bit_add[0].fa.co add1.bit_add[0].fa.sum sky130_fd_sc_hd__fa_1
Xadd1.bit_add[10].fa.fa add1.bit_add[10].fa.a net1 add1.bit_add[10].fa.ci VGND VGND VPWR VPWR add1.bit_add[10].fa.co add1.bit_add[10].fa.sum sky130_fd_sc_hd__fa_1
Xadd1.bit_add[11].fa.fa add1.bit_add[11].fa.a net1 add1.bit_add[10].fa.co VGND VGND VPWR VPWR add1.bit_add[11].fa.co add1.bit_add[11].fa.sum sky130_fd_sc_hd__fa_1
Xadd1.bit_add[12].fa.fa add1.bit_add[12].fa.a net1 add1.bit_add[11].fa.co VGND VGND VPWR VPWR add1.bit_add[12].fa.co add1.bit_add[12].fa.sum sky130_fd_sc_hd__fa_1
Xadd1.bit_add[13].fa.fa add1.bit_add[13].fa.a net1 add1.bit_add[12].fa.co VGND VGND VPWR VPWR add1.bit_add[13].fa.co add1.bit_add[13].fa.sum sky130_fd_sc_hd__fa_1
Xadd1.bit_add[14].fa.fa add1.bit_add[14].fa.a add1.bit_add[10].fa.b add1.bit_add[13].fa.co VGND VGND VPWR VPWR add1.bit_add[14].fa.co add1.bit_add[14].fa.sum sky130_fd_sc_hd__fa_1
Xadd1.bit_add[15].fa.fa add1.bit_add[15].fa.a add1.bit_add[10].fa.b add1.bit_add[14].fa.co VGND VGND VPWR VPWR add1.bit_add[15].fa.co add1.bit_add[15].fa.sum sky130_fd_sc_hd__fa_1
Xadd1.bit_add[16].fa.fa add1.bit_add[16].fa.a add1.bit_add[10].fa.b add1.bit_add[15].fa.co VGND VGND VPWR VPWR add1.bit_add[16].fa.co add1.bit_add[16].fa.sum sky130_fd_sc_hd__fa_1
Xadd1.bit_add[17].fa.fa add1.bit_add[17].fa.a add1.bit_add[10].fa.b add1.bit_add[16].fa.co VGND VGND VPWR VPWR add1.bit_add[17].fa.co add1.bit_add[17].fa.sum sky130_fd_sc_hd__fa_1
Xadd1.bit_add[18].fa.fa add1.bit_add[18].fa.a add1.bit_add[10].fa.b add1.bit_add[17].fa.co VGND VGND VPWR VPWR add1.bit_add[18].fa.co add1.bit_add[18].fa.sum sky130_fd_sc_hd__fa_1
Xadd1.bit_add[19].fa.fa add1.bit_add[19].fa.a add1.bit_add[10].fa.b add1.bit_add[18].fa.co VGND VGND VPWR VPWR add1.bit_add[19].fa.co add1.bit_add[19].fa.sum sky130_fd_sc_hd__fa_1
Xadd1.bit_add[1].fa.fa add1.bit_add[1].fa.a add1.bit_add[1].fa.b add1.bit_add[0].fa.co VGND VGND VPWR VPWR add1.bit_add[1].fa.co add1.bit_add[1].fa.sum sky130_fd_sc_hd__fa_1
Xadd1.bit_add[20].fa.fa add1.bit_add[20].fa.a add1.bit_add[10].fa.b add1.bit_add[19].fa.co VGND VGND VPWR VPWR add1.bit_add[20].fa.co add1.bit_add[20].fa.sum sky130_fd_sc_hd__fa_1
Xadd1.bit_add[2].fa.fa add1.bit_add[2].fa.a add1.bit_add[2].fa.b add1.bit_add[1].fa.co VGND VGND VPWR VPWR add1.bit_add[2].fa.co add1.bit_add[2].fa.sum sky130_fd_sc_hd__fa_1
Xadd1.bit_add[3].fa.fa add1.bit_add[3].fa.a add1.bit_add[3].fa.b add1.bit_add[2].fa.co VGND VGND VPWR VPWR add1.bit_add[3].fa.co add1.bit_add[3].fa.sum sky130_fd_sc_hd__fa_1
Xadd1.bit_add[4].fa.fa add1.bit_add[4].fa.a add1.bit_add[10].fa.b add1.bit_add[3].fa.co VGND VGND VPWR VPWR add1.bit_add[4].fa.co add1.bit_add[4].fa.sum sky130_fd_sc_hd__fa_1
Xadd1.bit_add[5].fa.fa add1.bit_add[5].fa.a net1 add1.bit_add[4].fa.co VGND VGND VPWR VPWR add1.bit_add[5].fa.co add1.bit_add[5].fa.sum sky130_fd_sc_hd__fa_1
Xadd1.bit_add[6].fa.fa add1.bit_add[6].fa.a net1 add1.bit_add[5].fa.co VGND VGND VPWR VPWR add1.bit_add[6].fa.co add1.bit_add[6].fa.sum sky130_fd_sc_hd__fa_1
Xadd1.bit_add[7].fa.fa add1.bit_add[7].fa.a net1 add1.bit_add[6].fa.co VGND VGND VPWR VPWR add1.bit_add[7].fa.co add1.bit_add[7].fa.sum sky130_fd_sc_hd__fa_1
Xadd1.bit_add[8].fa.fa add1.bit_add[8].fa.a net1 add1.bit_add[7].fa.co VGND VGND VPWR VPWR add1.bit_add[8].fa.co add1.bit_add[8].fa.sum sky130_fd_sc_hd__fa_1
Xadd1.bit_add[9].fa.fa add1.bit_add[9].fa.a net1 add1.bit_add[8].fa.co VGND VGND VPWR VPWR add1.bit_add[10].fa.ci add1.bit_add[9].fa.sum sky130_fd_sc_hd__fa_1
Xadd2.bit_add[0].fa.fa add2.bit_add[0].fa.a add1.bit_add[0].fa.a net5 VGND VGND VPWR VPWR add2.bit_add[0].fa.co add2.bit_add[0].fa.sum sky130_fd_sc_hd__fa_1
Xadd2.bit_add[10].fa.fa add2.bit_add[10].fa.a add1.bit_add[10].fa.a add2.bit_add[10].fa.ci VGND VGND VPWR VPWR add2.bit_add[10].fa.co add2.bit_add[10].fa.sum sky130_fd_sc_hd__fa_1
Xadd2.bit_add[11].fa.fa add2.bit_add[11].fa.a add1.bit_add[11].fa.a add2.bit_add[10].fa.co VGND VGND VPWR VPWR add2.bit_add[11].fa.co add2.bit_add[11].fa.sum sky130_fd_sc_hd__fa_1
Xadd2.bit_add[12].fa.fa add2.bit_add[12].fa.a add1.bit_add[12].fa.a add2.bit_add[11].fa.co VGND VGND VPWR VPWR add2.bit_add[12].fa.co add2.bit_add[12].fa.sum sky130_fd_sc_hd__fa_1
Xadd2.bit_add[13].fa.fa add2.bit_add[13].fa.a add1.bit_add[13].fa.a add2.bit_add[12].fa.co VGND VGND VPWR VPWR add2.bit_add[13].fa.co add2.bit_add[13].fa.sum sky130_fd_sc_hd__fa_1
Xadd2.bit_add[14].fa.fa add2.bit_add[14].fa.a add1.bit_add[14].fa.a add2.bit_add[13].fa.co VGND VGND VPWR VPWR add2.bit_add[14].fa.co add2.bit_add[14].fa.sum sky130_fd_sc_hd__fa_1
Xadd2.bit_add[15].fa.fa add2.bit_add[15].fa.a add1.bit_add[15].fa.a add2.bit_add[14].fa.co VGND VGND VPWR VPWR add2.bit_add[15].fa.co add2.bit_add[15].fa.sum sky130_fd_sc_hd__fa_1
Xadd2.bit_add[16].fa.fa add2.bit_add[16].fa.a add1.bit_add[16].fa.a add2.bit_add[15].fa.co VGND VGND VPWR VPWR add2.bit_add[16].fa.co add2.bit_add[16].fa.sum sky130_fd_sc_hd__fa_1
Xadd2.bit_add[17].fa.fa add2.bit_add[17].fa.a add1.bit_add[17].fa.a add2.bit_add[16].fa.co VGND VGND VPWR VPWR add2.bit_add[17].fa.co add2.bit_add[17].fa.sum sky130_fd_sc_hd__fa_1
Xadd2.bit_add[18].fa.fa add2.bit_add[18].fa.a add1.bit_add[18].fa.a add2.bit_add[17].fa.co VGND VGND VPWR VPWR add2.bit_add[18].fa.co add2.bit_add[18].fa.sum sky130_fd_sc_hd__fa_1
Xadd2.bit_add[19].fa.fa add2.bit_add[19].fa.a add1.bit_add[19].fa.a add2.bit_add[18].fa.co VGND VGND VPWR VPWR add2.bit_add[19].fa.co add2.bit_add[19].fa.sum sky130_fd_sc_hd__fa_1
Xadd2.bit_add[1].fa.fa add2.bit_add[1].fa.a add1.bit_add[1].fa.a add2.bit_add[0].fa.co VGND VGND VPWR VPWR add2.bit_add[1].fa.co add2.bit_add[1].fa.sum sky130_fd_sc_hd__fa_1
Xadd2.bit_add[20].fa.fa add2.bit_add[20].fa.a add1.bit_add[20].fa.a add2.bit_add[19].fa.co VGND VGND VPWR VPWR add2.bit_add[20].fa.co add2.bit_add[20].fa.sum sky130_fd_sc_hd__fa_1
Xadd2.bit_add[2].fa.fa add2.bit_add[2].fa.a add1.bit_add[2].fa.a add2.bit_add[1].fa.co VGND VGND VPWR VPWR add2.bit_add[2].fa.co add2.bit_add[2].fa.sum sky130_fd_sc_hd__fa_1
Xadd2.bit_add[3].fa.fa add2.bit_add[3].fa.a add1.bit_add[3].fa.a add2.bit_add[2].fa.co VGND VGND VPWR VPWR add2.bit_add[3].fa.co add2.bit_add[3].fa.sum sky130_fd_sc_hd__fa_1
Xadd2.bit_add[4].fa.fa add2.bit_add[4].fa.a add1.bit_add[4].fa.a add2.bit_add[3].fa.co VGND VGND VPWR VPWR add2.bit_add[4].fa.co add2.bit_add[4].fa.sum sky130_fd_sc_hd__fa_1
Xadd2.bit_add[5].fa.fa add2.bit_add[5].fa.a add1.bit_add[5].fa.a add2.bit_add[4].fa.co VGND VGND VPWR VPWR add2.bit_add[5].fa.co add2.bit_add[5].fa.sum sky130_fd_sc_hd__fa_1
Xadd2.bit_add[6].fa.fa add2.bit_add[6].fa.a add1.bit_add[6].fa.a add2.bit_add[5].fa.co VGND VGND VPWR VPWR add2.bit_add[6].fa.co add2.bit_add[6].fa.sum sky130_fd_sc_hd__fa_1
Xadd2.bit_add[7].fa.fa add2.bit_add[7].fa.a add1.bit_add[7].fa.a add2.bit_add[6].fa.co VGND VGND VPWR VPWR add2.bit_add[7].fa.co add2.bit_add[7].fa.sum sky130_fd_sc_hd__fa_1
Xadd2.bit_add[8].fa.fa add2.bit_add[8].fa.a add1.bit_add[8].fa.a add2.bit_add[7].fa.co VGND VGND VPWR VPWR add2.bit_add[8].fa.co add2.bit_add[8].fa.sum sky130_fd_sc_hd__fa_1
Xadd2.bit_add[9].fa.fa add2.bit_add[9].fa.a add1.bit_add[9].fa.a add2.bit_add[8].fa.co VGND VGND VPWR VPWR add2.bit_add[10].fa.ci add2.bit_add[9].fa.sum sky130_fd_sc_hd__fa_1
Xbit_store[0].ff clknet_1_0__leaf_g_work.gclk shift_word[0] net25 capture VGND VGND VPWR VPWR a sky130_fd_sc_hd__sdfxtp_1
Xbit_store[10].ff clknet_1_1__leaf_g_work.gclk work[11] net21 capture VGND VGND VPWR VPWR work[10] sky130_fd_sc_hd__sdfxtp_1
Xbit_store[11].ff clknet_1_1__leaf_g_work.gclk work[12] net20 capture VGND VGND VPWR VPWR work[11] sky130_fd_sc_hd__sdfxtp_1
Xbit_store[12].ff clknet_1_1__leaf_g_work.gclk work[13] net23 capture VGND VGND VPWR VPWR work[12] sky130_fd_sc_hd__sdfxtp_1
Xbit_store[13].ff clknet_1_1__leaf_g_work.gclk work[14] net9 capture VGND VGND VPWR VPWR work[13] sky130_fd_sc_hd__sdfxtp_1
Xbit_store[14].ff clknet_1_1__leaf_g_work.gclk work[15] net10 capture VGND VGND VPWR VPWR work[14] sky130_fd_sc_hd__sdfxtp_1
Xbit_store[15].ff clknet_1_1__leaf_g_work.gclk work[16] net13 capture VGND VGND VPWR VPWR work[15] sky130_fd_sc_hd__sdfxtp_1
Xbit_store[16].ff clknet_1_0__leaf_g_work.gclk work[17] net19 capture VGND VGND VPWR VPWR work[16] sky130_fd_sc_hd__sdfxtp_1
Xbit_store[17].ff clknet_1_0__leaf_g_work.gclk work[18] net16 capture VGND VGND VPWR VPWR work[17] sky130_fd_sc_hd__sdfxtp_1
Xbit_store[18].ff clknet_1_0__leaf_g_work.gclk work[19] net15 capture VGND VGND VPWR VPWR work[18] sky130_fd_sc_hd__sdfxtp_1
Xbit_store[19].ff clknet_1_0__leaf_g_work.gclk work[20] net8 capture VGND VGND VPWR VPWR work[19] sky130_fd_sc_hd__sdfxtp_1
Xbit_store[1].ff clknet_1_0__leaf_g_work.gclk shift_word[1] net12 capture VGND VGND VPWR VPWR shift_word[0] sky130_fd_sc_hd__sdfxtp_1
Xbit_store[20].ff clknet_1_0__leaf_g_work.gclk second net18 capture VGND VGND VPWR VPWR work[20] sky130_fd_sc_hd__sdfxtp_1
Xbit_store[2].ff clknet_1_0__leaf_g_work.gclk work[3] net17 capture VGND VGND VPWR VPWR shift_word[1] sky130_fd_sc_hd__sdfxtp_1
Xbit_store[3].ff clknet_1_0__leaf_g_work.gclk work[4] net14 capture VGND VGND VPWR VPWR work[3] sky130_fd_sc_hd__sdfxtp_1
Xbit_store[4].ff clknet_1_1__leaf_g_work.gclk work[5] net11 capture VGND VGND VPWR VPWR work[4] sky130_fd_sc_hd__sdfxtp_1
Xbit_store[5].ff clknet_1_1__leaf_g_work.gclk work[6] net27 capture VGND VGND VPWR VPWR work[5] sky130_fd_sc_hd__sdfxtp_1
Xbit_store[6].ff clknet_1_1__leaf_g_work.gclk work[7] net28 capture VGND VGND VPWR VPWR work[6] sky130_fd_sc_hd__sdfxtp_1
Xbit_store[7].ff clknet_1_1__leaf_g_work.gclk work[8] net26 capture VGND VGND VPWR VPWR work[7] sky130_fd_sc_hd__sdfxtp_1
Xbit_store[8].ff clknet_1_1__leaf_g_work.gclk work[9] net22 capture VGND VGND VPWR VPWR work[8] sky130_fd_sc_hd__sdfxtp_1
Xbit_store[9].ff clknet_1_1__leaf_g_work.gclk work[10] net24 capture VGND VGND VPWR VPWR work[9] sky130_fd_sc_hd__sdfxtp_1
Xg_delay.cg clknet_4_5_0_clk g_delay.en VGND VGND VPWR VPWR g_delay.gclk sky130_fd_sc_hd__dlclkp_1
Xg_work.cg clknet_4_5_0_clk g_work.en VGND VGND VPWR VPWR g_work.gclk sky130_fd_sc_hd__dlclkp_1
Xpn.column[0].fa.fa pn.column[0].fa.a pn.column[0].fa.b pn.column[0].fa.ci VGND VGND VPWR VPWR pn.column[0].fa.co pn.column[0].fa.sum sky130_fd_sc_hd__fa_1
Xpn.column[1].fa.fa pn.column[1].fa.a pn.column[1].fa.b pn.column[1].fa.ci VGND VGND VPWR VPWR pn.column[1].fa.co pn.column[1].fa.sum sky130_fd_sc_hd__fa_1
Xpn.column[2].fa.fa pn.column[2].fa.a pn.column[2].fa.b pn.column[2].fa.ci VGND VGND VPWR VPWR pn.column[2].fa.co pn.column[2].fa.sum sky130_fd_sc_hd__fa_1
Xpn.column[3].fa.fa pn.column[3].fa.a pn.column[3].fa.b pn.column[3].fa.ci VGND VGND VPWR VPWR pn.column[3].fa.co pn.column[3].fa.sum sky130_fd_sc_hd__fa_1
Xpn.column[4].fa.fa pn.column[4].fa.a pn.column[4].fa.b pn.column[4].fa.ci VGND VGND VPWR VPWR pn.column[4].fa.co pn.column[4].fa.sum sky130_fd_sc_hd__fa_1
Xpn.f0.fa pn.column[0].fa.sum pn.column[1].fa.sum pn.column[2].fa.sum VGND VGND VPWR VPWR pn.f0.co pn.f0.sum sky130_fd_sc_hd__fa_1
Xpn.f1.fa pn.column[3].fa.sum pn.column[4].fa.sum pn.f0.sum VGND VGND VPWR VPWR pn.f1.co pn.f1.sum sky130_fd_sc_hd__fa_2
Xpn.f2.fa pn.column[0].fa.co pn.column[1].fa.co pn.column[2].fa.co VGND VGND VPWR VPWR pn.f2.co pn.f2.sum sky130_fd_sc_hd__fa_1
Xpn.f3.fa pn.column[3].fa.co pn.column[4].fa.co pn.f0.co VGND VGND VPWR VPWR pn.f3.co pn.f3.sum sky130_fd_sc_hd__fa_1
Xpn.f4.fa pn.f2.sum pn.f3.sum pn.f1.co VGND VGND VPWR VPWR pn.f4.co pn.f4.sum sky130_fd_sc_hd__fa_2
Xpn.f5.fa pn.f2.co pn.f3.co pn.f4.co VGND VGND VPWR VPWR pn.f5.co pn.f5.sum sky130_fd_sc_hd__fa_2
Xpp.column[0].fa.fa pp.column[0].fa.a pp.column[0].fa.b pp.column[0].fa.ci VGND VGND VPWR VPWR pp.column[0].fa.co pp.column[0].fa.sum sky130_fd_sc_hd__fa_1
Xpp.column[1].fa.fa pp.column[1].fa.a pp.column[1].fa.b pp.column[1].fa.ci VGND VGND VPWR VPWR pp.column[1].fa.co pp.column[1].fa.sum sky130_fd_sc_hd__fa_1
Xpp.column[2].fa.fa pp.column[2].fa.a pp.column[2].fa.b pp.column[2].fa.ci VGND VGND VPWR VPWR pp.column[2].fa.co pp.column[2].fa.sum sky130_fd_sc_hd__fa_1
Xpp.column[3].fa.fa pp.column[3].fa.a pp.column[3].fa.b pp.column[3].fa.ci VGND VGND VPWR VPWR pp.column[3].fa.co pp.column[3].fa.sum sky130_fd_sc_hd__fa_1
Xpp.column[4].fa.fa pp.column[4].fa.a pp.column[4].fa.b pp.column[4].fa.ci VGND VGND VPWR VPWR pp.column[4].fa.co pp.column[4].fa.sum sky130_fd_sc_hd__fa_1
Xpp.f0.fa pp.column[0].fa.sum pp.column[1].fa.sum pp.column[2].fa.sum VGND VGND VPWR VPWR pp.f0.co pp.f0.sum sky130_fd_sc_hd__fa_1
Xpp.f1.fa pp.column[3].fa.sum pp.column[4].fa.sum pp.f0.sum VGND VGND VPWR VPWR pp.f1.co pp.f1.sum sky130_fd_sc_hd__fa_2
Xpp.f2.fa pp.column[0].fa.co pp.column[1].fa.co pp.column[2].fa.co VGND VGND VPWR VPWR pp.f2.co pp.f2.sum sky130_fd_sc_hd__fa_1
Xpp.f3.fa pp.column[3].fa.co pp.column[4].fa.co pp.f0.co VGND VGND VPWR VPWR pp.f3.co pp.f3.sum sky130_fd_sc_hd__fa_1
Xpp.f4.fa pp.f2.sum pp.f3.sum pp.f1.co VGND VGND VPWR VPWR pp.f4.co pp.f4.sum sky130_fd_sc_hd__fa_2
Xpp.f5.fa pp.f2.co pp.f3.co pp.f4.co VGND VGND VPWR VPWR pp.f5.co pp.f5.sum sky130_fd_sc_hd__fa_2
Xvn.cg.cg clknet_1_0__leaf_tap_n[0] vn.cg.en VGND VGND VPWR VPWR vn.cg.gclk sky130_fd_sc_hd__dlclkp_1
Xvp.cg.cg clknet_1_1__leaf_tap_p[0] vn.cg.en VGND VGND VPWR VPWR vp.cg.gclk sky130_fd_sc_hd__dlclkp_1
X_396__6 VGND VGND VPWR VPWR net6 open__396__6_LO sky130_fd_sc_hd__conb_1
Xclkbuf_0_clk clk VGND VGND VPWR VPWR clknet_0_clk sky130_fd_sc_hd__clkbuf_4
XPHY_EDGE_ROW_0_Right_0 VGND VGND VPWR VPWR sky130_fd_sc_hd__decap_3
XPHY_EDGE_ROW_1_Right_1 VGND VGND VPWR VPWR sky130_fd_sc_hd__decap_3
XPHY_EDGE_ROW_2_Right_2 VGND VGND VPWR VPWR sky130_fd_sc_hd__decap_3
XPHY_EDGE_ROW_3_Right_3 VGND VGND VPWR VPWR sky130_fd_sc_hd__decap_3
XPHY_EDGE_ROW_4_Right_4 VGND VGND VPWR VPWR sky130_fd_sc_hd__decap_3
XPHY_EDGE_ROW_5_Right_5 VGND VGND VPWR VPWR sky130_fd_sc_hd__decap_3
XPHY_EDGE_ROW_6_Right_6 VGND VGND VPWR VPWR sky130_fd_sc_hd__decap_3
XPHY_EDGE_ROW_7_Right_7 VGND VGND VPWR VPWR sky130_fd_sc_hd__decap_3
XPHY_EDGE_ROW_8_Right_8 VGND VGND VPWR VPWR sky130_fd_sc_hd__decap_3
XPHY_EDGE_ROW_9_Right_9 VGND VGND VPWR VPWR sky130_fd_sc_hd__decap_3
XPHY_EDGE_ROW_10_Right_10 VGND VGND VPWR VPWR sky130_fd_sc_hd__decap_3
XPHY_EDGE_ROW_11_Right_11 VGND VGND VPWR VPWR sky130_fd_sc_hd__decap_3
XPHY_EDGE_ROW_12_Right_12 VGND VGND VPWR VPWR sky130_fd_sc_hd__decap_3
XPHY_EDGE_ROW_13_Right_13 VGND VGND VPWR VPWR sky130_fd_sc_hd__decap_3
XPHY_EDGE_ROW_14_Right_14 VGND VGND VPWR VPWR sky130_fd_sc_hd__decap_3
XPHY_EDGE_ROW_15_Right_15 VGND VGND VPWR VPWR sky130_fd_sc_hd__decap_3
XPHY_EDGE_ROW_16_Right_16 VGND VGND VPWR VPWR sky130_fd_sc_hd__decap_3
XPHY_EDGE_ROW_17_Right_17 VGND VGND VPWR VPWR sky130_fd_sc_hd__decap_3
XPHY_EDGE_ROW_18_Right_18 VGND VGND VPWR VPWR sky130_fd_sc_hd__decap_3
XPHY_EDGE_ROW_19_Right_19 VGND VGND VPWR VPWR sky130_fd_sc_hd__decap_3
XPHY_EDGE_ROW_20_Right_20 VGND VGND VPWR VPWR sky130_fd_sc_hd__decap_3
XPHY_EDGE_ROW_21_Right_21 VGND VGND VPWR VPWR sky130_fd_sc_hd__decap_3
XPHY_EDGE_ROW_22_Right_22 VGND VGND VPWR VPWR sky130_fd_sc_hd__decap_3
XPHY_EDGE_ROW_23_Right_23 VGND VGND VPWR VPWR sky130_fd_sc_hd__decap_3
XPHY_EDGE_ROW_24_Right_24 VGND VGND VPWR VPWR sky130_fd_sc_hd__decap_3
XPHY_EDGE_ROW_25_Right_25 VGND VGND VPWR VPWR sky130_fd_sc_hd__decap_3
XPHY_EDGE_ROW_26_Right_26 VGND VGND VPWR VPWR sky130_fd_sc_hd__decap_3
XPHY_EDGE_ROW_27_Right_27 VGND VGND VPWR VPWR sky130_fd_sc_hd__decap_3
XPHY_EDGE_ROW_28_Right_28 VGND VGND VPWR VPWR sky130_fd_sc_hd__decap_3
XPHY_EDGE_ROW_29_Right_29 VGND VGND VPWR VPWR sky130_fd_sc_hd__decap_3
XPHY_EDGE_ROW_30_Right_30 VGND VGND VPWR VPWR sky130_fd_sc_hd__decap_3
XPHY_EDGE_ROW_31_Right_31 VGND VGND VPWR VPWR sky130_fd_sc_hd__decap_3
XPHY_EDGE_ROW_32_Right_32 VGND VGND VPWR VPWR sky130_fd_sc_hd__decap_3
XPHY_EDGE_ROW_33_Right_33 VGND VGND VPWR VPWR sky130_fd_sc_hd__decap_3
XPHY_EDGE_ROW_0_Left_34 VGND VGND VPWR VPWR sky130_fd_sc_hd__decap_3
XPHY_EDGE_ROW_1_Left_35 VGND VGND VPWR VPWR sky130_fd_sc_hd__decap_3
XPHY_EDGE_ROW_2_Left_36 VGND VGND VPWR VPWR sky130_fd_sc_hd__decap_3
XPHY_EDGE_ROW_3_Left_37 VGND VGND VPWR VPWR sky130_fd_sc_hd__decap_3
XPHY_EDGE_ROW_4_Left_38 VGND VGND VPWR VPWR sky130_fd_sc_hd__decap_3
XPHY_EDGE_ROW_5_Left_39 VGND VGND VPWR VPWR sky130_fd_sc_hd__decap_3
XPHY_EDGE_ROW_6_Left_40 VGND VGND VPWR VPWR sky130_fd_sc_hd__decap_3
XPHY_EDGE_ROW_7_Left_41 VGND VGND VPWR VPWR sky130_fd_sc_hd__decap_3
XPHY_EDGE_ROW_8_Left_42 VGND VGND VPWR VPWR sky130_fd_sc_hd__decap_3
XPHY_EDGE_ROW_9_Left_43 VGND VGND VPWR VPWR sky130_fd_sc_hd__decap_3
XPHY_EDGE_ROW_10_Left_44 VGND VGND VPWR VPWR sky130_fd_sc_hd__decap_3
XPHY_EDGE_ROW_11_Left_45 VGND VGND VPWR VPWR sky130_fd_sc_hd__decap_3
XPHY_EDGE_ROW_12_Left_46 VGND VGND VPWR VPWR sky130_fd_sc_hd__decap_3
XPHY_EDGE_ROW_13_Left_47 VGND VGND VPWR VPWR sky130_fd_sc_hd__decap_3
XPHY_EDGE_ROW_14_Left_48 VGND VGND VPWR VPWR sky130_fd_sc_hd__decap_3
XPHY_EDGE_ROW_15_Left_49 VGND VGND VPWR VPWR sky130_fd_sc_hd__decap_3
XPHY_EDGE_ROW_16_Left_50 VGND VGND VPWR VPWR sky130_fd_sc_hd__decap_3
XPHY_EDGE_ROW_17_Left_51 VGND VGND VPWR VPWR sky130_fd_sc_hd__decap_3
XPHY_EDGE_ROW_18_Left_52 VGND VGND VPWR VPWR sky130_fd_sc_hd__decap_3
XPHY_EDGE_ROW_19_Left_53 VGND VGND VPWR VPWR sky130_fd_sc_hd__decap_3
XPHY_EDGE_ROW_20_Left_54 VGND VGND VPWR VPWR sky130_fd_sc_hd__decap_3
XPHY_EDGE_ROW_21_Left_55 VGND VGND VPWR VPWR sky130_fd_sc_hd__decap_3
XPHY_EDGE_ROW_22_Left_56 VGND VGND VPWR VPWR sky130_fd_sc_hd__decap_3
XPHY_EDGE_ROW_23_Left_57 VGND VGND VPWR VPWR sky130_fd_sc_hd__decap_3
XPHY_EDGE_ROW_24_Left_58 VGND VGND VPWR VPWR sky130_fd_sc_hd__decap_3
XPHY_EDGE_ROW_25_Left_59 VGND VGND VPWR VPWR sky130_fd_sc_hd__decap_3
XPHY_EDGE_ROW_26_Left_60 VGND VGND VPWR VPWR sky130_fd_sc_hd__decap_3
XPHY_EDGE_ROW_27_Left_61 VGND VGND VPWR VPWR sky130_fd_sc_hd__decap_3
XPHY_EDGE_ROW_28_Left_62 VGND VGND VPWR VPWR sky130_fd_sc_hd__decap_3
XPHY_EDGE_ROW_29_Left_63 VGND VGND VPWR VPWR sky130_fd_sc_hd__decap_3
XPHY_EDGE_ROW_30_Left_64 VGND VGND VPWR VPWR sky130_fd_sc_hd__decap_3
XPHY_EDGE_ROW_31_Left_65 VGND VGND VPWR VPWR sky130_fd_sc_hd__decap_3
XPHY_EDGE_ROW_32_Left_66 VGND VGND VPWR VPWR sky130_fd_sc_hd__decap_3
XPHY_EDGE_ROW_33_Left_67 VGND VGND VPWR VPWR sky130_fd_sc_hd__decap_3
XTAP_TAPCELL_ROW_0_68 VGND VPWR sky130_fd_sc_hd__tapvpwrvgnd_1
XTAP_TAPCELL_ROW_0_69 VGND VPWR sky130_fd_sc_hd__tapvpwrvgnd_1
XTAP_TAPCELL_ROW_0_70 VGND VPWR sky130_fd_sc_hd__tapvpwrvgnd_1
XTAP_TAPCELL_ROW_0_71 VGND VPWR sky130_fd_sc_hd__tapvpwrvgnd_1
XTAP_TAPCELL_ROW_0_72 VGND VPWR sky130_fd_sc_hd__tapvpwrvgnd_1
XTAP_TAPCELL_ROW_0_73 VGND VPWR sky130_fd_sc_hd__tapvpwrvgnd_1
XTAP_TAPCELL_ROW_0_74 VGND VPWR sky130_fd_sc_hd__tapvpwrvgnd_1
XTAP_TAPCELL_ROW_0_75 VGND VPWR sky130_fd_sc_hd__tapvpwrvgnd_1
XTAP_TAPCELL_ROW_0_76 VGND VPWR sky130_fd_sc_hd__tapvpwrvgnd_1
XTAP_TAPCELL_ROW_0_77 VGND VPWR sky130_fd_sc_hd__tapvpwrvgnd_1
XTAP_TAPCELL_ROW_0_78 VGND VPWR sky130_fd_sc_hd__tapvpwrvgnd_1
XTAP_TAPCELL_ROW_1_79 VGND VPWR sky130_fd_sc_hd__tapvpwrvgnd_1
XTAP_TAPCELL_ROW_1_80 VGND VPWR sky130_fd_sc_hd__tapvpwrvgnd_1
XTAP_TAPCELL_ROW_1_81 VGND VPWR sky130_fd_sc_hd__tapvpwrvgnd_1
XTAP_TAPCELL_ROW_1_82 VGND VPWR sky130_fd_sc_hd__tapvpwrvgnd_1
XTAP_TAPCELL_ROW_1_83 VGND VPWR sky130_fd_sc_hd__tapvpwrvgnd_1
XTAP_TAPCELL_ROW_2_84 VGND VPWR sky130_fd_sc_hd__tapvpwrvgnd_1
XTAP_TAPCELL_ROW_2_85 VGND VPWR sky130_fd_sc_hd__tapvpwrvgnd_1
XTAP_TAPCELL_ROW_2_86 VGND VPWR sky130_fd_sc_hd__tapvpwrvgnd_1
XTAP_TAPCELL_ROW_2_87 VGND VPWR sky130_fd_sc_hd__tapvpwrvgnd_1
XTAP_TAPCELL_ROW_2_88 VGND VPWR sky130_fd_sc_hd__tapvpwrvgnd_1
XTAP_TAPCELL_ROW_2_89 VGND VPWR sky130_fd_sc_hd__tapvpwrvgnd_1
XTAP_TAPCELL_ROW_3_90 VGND VPWR sky130_fd_sc_hd__tapvpwrvgnd_1
XTAP_TAPCELL_ROW_3_91 VGND VPWR sky130_fd_sc_hd__tapvpwrvgnd_1
XTAP_TAPCELL_ROW_3_92 VGND VPWR sky130_fd_sc_hd__tapvpwrvgnd_1
XTAP_TAPCELL_ROW_3_93 VGND VPWR sky130_fd_sc_hd__tapvpwrvgnd_1
XTAP_TAPCELL_ROW_3_94 VGND VPWR sky130_fd_sc_hd__tapvpwrvgnd_1
XTAP_TAPCELL_ROW_4_95 VGND VPWR sky130_fd_sc_hd__tapvpwrvgnd_1
XTAP_TAPCELL_ROW_4_96 VGND VPWR sky130_fd_sc_hd__tapvpwrvgnd_1
XTAP_TAPCELL_ROW_4_97 VGND VPWR sky130_fd_sc_hd__tapvpwrvgnd_1
XTAP_TAPCELL_ROW_4_98 VGND VPWR sky130_fd_sc_hd__tapvpwrvgnd_1
XTAP_TAPCELL_ROW_4_99 VGND VPWR sky130_fd_sc_hd__tapvpwrvgnd_1
XTAP_TAPCELL_ROW_4_100 VGND VPWR sky130_fd_sc_hd__tapvpwrvgnd_1
XTAP_TAPCELL_ROW_5_101 VGND VPWR sky130_fd_sc_hd__tapvpwrvgnd_1
XTAP_TAPCELL_ROW_5_102 VGND VPWR sky130_fd_sc_hd__tapvpwrvgnd_1
XTAP_TAPCELL_ROW_5_103 VGND VPWR sky130_fd_sc_hd__tapvpwrvgnd_1
XTAP_TAPCELL_ROW_5_104 VGND VPWR sky130_fd_sc_hd__tapvpwrvgnd_1
XTAP_TAPCELL_ROW_5_105 VGND VPWR sky130_fd_sc_hd__tapvpwrvgnd_1
XTAP_TAPCELL_ROW_6_106 VGND VPWR sky130_fd_sc_hd__tapvpwrvgnd_1
XTAP_TAPCELL_ROW_6_107 VGND VPWR sky130_fd_sc_hd__tapvpwrvgnd_1
XTAP_TAPCELL_ROW_6_108 VGND VPWR sky130_fd_sc_hd__tapvpwrvgnd_1
XTAP_TAPCELL_ROW_6_109 VGND VPWR sky130_fd_sc_hd__tapvpwrvgnd_1
XTAP_TAPCELL_ROW_6_110 VGND VPWR sky130_fd_sc_hd__tapvpwrvgnd_1
XTAP_TAPCELL_ROW_6_111 VGND VPWR sky130_fd_sc_hd__tapvpwrvgnd_1
XTAP_TAPCELL_ROW_7_112 VGND VPWR sky130_fd_sc_hd__tapvpwrvgnd_1
XTAP_TAPCELL_ROW_7_113 VGND VPWR sky130_fd_sc_hd__tapvpwrvgnd_1
XTAP_TAPCELL_ROW_7_114 VGND VPWR sky130_fd_sc_hd__tapvpwrvgnd_1
XTAP_TAPCELL_ROW_7_115 VGND VPWR sky130_fd_sc_hd__tapvpwrvgnd_1
XTAP_TAPCELL_ROW_7_116 VGND VPWR sky130_fd_sc_hd__tapvpwrvgnd_1
XTAP_TAPCELL_ROW_8_117 VGND VPWR sky130_fd_sc_hd__tapvpwrvgnd_1
XTAP_TAPCELL_ROW_8_118 VGND VPWR sky130_fd_sc_hd__tapvpwrvgnd_1
XTAP_TAPCELL_ROW_8_119 VGND VPWR sky130_fd_sc_hd__tapvpwrvgnd_1
XTAP_TAPCELL_ROW_8_120 VGND VPWR sky130_fd_sc_hd__tapvpwrvgnd_1
XTAP_TAPCELL_ROW_8_121 VGND VPWR sky130_fd_sc_hd__tapvpwrvgnd_1
XTAP_TAPCELL_ROW_8_122 VGND VPWR sky130_fd_sc_hd__tapvpwrvgnd_1
XTAP_TAPCELL_ROW_9_123 VGND VPWR sky130_fd_sc_hd__tapvpwrvgnd_1
XTAP_TAPCELL_ROW_9_124 VGND VPWR sky130_fd_sc_hd__tapvpwrvgnd_1
XTAP_TAPCELL_ROW_9_125 VGND VPWR sky130_fd_sc_hd__tapvpwrvgnd_1
XTAP_TAPCELL_ROW_9_126 VGND VPWR sky130_fd_sc_hd__tapvpwrvgnd_1
XTAP_TAPCELL_ROW_9_127 VGND VPWR sky130_fd_sc_hd__tapvpwrvgnd_1
XTAP_TAPCELL_ROW_10_128 VGND VPWR sky130_fd_sc_hd__tapvpwrvgnd_1
XTAP_TAPCELL_ROW_10_129 VGND VPWR sky130_fd_sc_hd__tapvpwrvgnd_1
XTAP_TAPCELL_ROW_10_130 VGND VPWR sky130_fd_sc_hd__tapvpwrvgnd_1
XTAP_TAPCELL_ROW_10_131 VGND VPWR sky130_fd_sc_hd__tapvpwrvgnd_1
XTAP_TAPCELL_ROW_10_132 VGND VPWR sky130_fd_sc_hd__tapvpwrvgnd_1
XTAP_TAPCELL_ROW_10_133 VGND VPWR sky130_fd_sc_hd__tapvpwrvgnd_1
XTAP_TAPCELL_ROW_11_134 VGND VPWR sky130_fd_sc_hd__tapvpwrvgnd_1
XTAP_TAPCELL_ROW_11_135 VGND VPWR sky130_fd_sc_hd__tapvpwrvgnd_1
XTAP_TAPCELL_ROW_11_136 VGND VPWR sky130_fd_sc_hd__tapvpwrvgnd_1
XTAP_TAPCELL_ROW_11_137 VGND VPWR sky130_fd_sc_hd__tapvpwrvgnd_1
XTAP_TAPCELL_ROW_11_138 VGND VPWR sky130_fd_sc_hd__tapvpwrvgnd_1
XTAP_TAPCELL_ROW_12_139 VGND VPWR sky130_fd_sc_hd__tapvpwrvgnd_1
XTAP_TAPCELL_ROW_12_140 VGND VPWR sky130_fd_sc_hd__tapvpwrvgnd_1
XTAP_TAPCELL_ROW_12_141 VGND VPWR sky130_fd_sc_hd__tapvpwrvgnd_1
XTAP_TAPCELL_ROW_12_142 VGND VPWR sky130_fd_sc_hd__tapvpwrvgnd_1
XTAP_TAPCELL_ROW_12_143 VGND VPWR sky130_fd_sc_hd__tapvpwrvgnd_1
XTAP_TAPCELL_ROW_12_144 VGND VPWR sky130_fd_sc_hd__tapvpwrvgnd_1
XTAP_TAPCELL_ROW_13_145 VGND VPWR sky130_fd_sc_hd__tapvpwrvgnd_1
XTAP_TAPCELL_ROW_13_146 VGND VPWR sky130_fd_sc_hd__tapvpwrvgnd_1
XTAP_TAPCELL_ROW_13_147 VGND VPWR sky130_fd_sc_hd__tapvpwrvgnd_1
XTAP_TAPCELL_ROW_13_148 VGND VPWR sky130_fd_sc_hd__tapvpwrvgnd_1
XTAP_TAPCELL_ROW_13_149 VGND VPWR sky130_fd_sc_hd__tapvpwrvgnd_1
XTAP_TAPCELL_ROW_14_150 VGND VPWR sky130_fd_sc_hd__tapvpwrvgnd_1
XTAP_TAPCELL_ROW_14_151 VGND VPWR sky130_fd_sc_hd__tapvpwrvgnd_1
XTAP_TAPCELL_ROW_14_152 VGND VPWR sky130_fd_sc_hd__tapvpwrvgnd_1
XTAP_TAPCELL_ROW_14_153 VGND VPWR sky130_fd_sc_hd__tapvpwrvgnd_1
XTAP_TAPCELL_ROW_14_154 VGND VPWR sky130_fd_sc_hd__tapvpwrvgnd_1
XTAP_TAPCELL_ROW_14_155 VGND VPWR sky130_fd_sc_hd__tapvpwrvgnd_1
XTAP_TAPCELL_ROW_15_156 VGND VPWR sky130_fd_sc_hd__tapvpwrvgnd_1
XTAP_TAPCELL_ROW_15_157 VGND VPWR sky130_fd_sc_hd__tapvpwrvgnd_1
XTAP_TAPCELL_ROW_15_158 VGND VPWR sky130_fd_sc_hd__tapvpwrvgnd_1
XTAP_TAPCELL_ROW_15_159 VGND VPWR sky130_fd_sc_hd__tapvpwrvgnd_1
XTAP_TAPCELL_ROW_15_160 VGND VPWR sky130_fd_sc_hd__tapvpwrvgnd_1
XTAP_TAPCELL_ROW_16_161 VGND VPWR sky130_fd_sc_hd__tapvpwrvgnd_1
XTAP_TAPCELL_ROW_16_162 VGND VPWR sky130_fd_sc_hd__tapvpwrvgnd_1
XTAP_TAPCELL_ROW_16_163 VGND VPWR sky130_fd_sc_hd__tapvpwrvgnd_1
XTAP_TAPCELL_ROW_16_164 VGND VPWR sky130_fd_sc_hd__tapvpwrvgnd_1
XTAP_TAPCELL_ROW_16_165 VGND VPWR sky130_fd_sc_hd__tapvpwrvgnd_1
XTAP_TAPCELL_ROW_16_166 VGND VPWR sky130_fd_sc_hd__tapvpwrvgnd_1
XTAP_TAPCELL_ROW_17_167 VGND VPWR sky130_fd_sc_hd__tapvpwrvgnd_1
XTAP_TAPCELL_ROW_17_168 VGND VPWR sky130_fd_sc_hd__tapvpwrvgnd_1
XTAP_TAPCELL_ROW_17_169 VGND VPWR sky130_fd_sc_hd__tapvpwrvgnd_1
XTAP_TAPCELL_ROW_17_170 VGND VPWR sky130_fd_sc_hd__tapvpwrvgnd_1
XTAP_TAPCELL_ROW_17_171 VGND VPWR sky130_fd_sc_hd__tapvpwrvgnd_1
XTAP_TAPCELL_ROW_18_172 VGND VPWR sky130_fd_sc_hd__tapvpwrvgnd_1
XTAP_TAPCELL_ROW_18_173 VGND VPWR sky130_fd_sc_hd__tapvpwrvgnd_1
XTAP_TAPCELL_ROW_18_174 VGND VPWR sky130_fd_sc_hd__tapvpwrvgnd_1
XTAP_TAPCELL_ROW_18_175 VGND VPWR sky130_fd_sc_hd__tapvpwrvgnd_1
XTAP_TAPCELL_ROW_18_176 VGND VPWR sky130_fd_sc_hd__tapvpwrvgnd_1
XTAP_TAPCELL_ROW_18_177 VGND VPWR sky130_fd_sc_hd__tapvpwrvgnd_1
XTAP_TAPCELL_ROW_19_178 VGND VPWR sky130_fd_sc_hd__tapvpwrvgnd_1
XTAP_TAPCELL_ROW_19_179 VGND VPWR sky130_fd_sc_hd__tapvpwrvgnd_1
XTAP_TAPCELL_ROW_19_180 VGND VPWR sky130_fd_sc_hd__tapvpwrvgnd_1
XTAP_TAPCELL_ROW_19_181 VGND VPWR sky130_fd_sc_hd__tapvpwrvgnd_1
XTAP_TAPCELL_ROW_19_182 VGND VPWR sky130_fd_sc_hd__tapvpwrvgnd_1
XTAP_TAPCELL_ROW_20_183 VGND VPWR sky130_fd_sc_hd__tapvpwrvgnd_1
XTAP_TAPCELL_ROW_20_184 VGND VPWR sky130_fd_sc_hd__tapvpwrvgnd_1
XTAP_TAPCELL_ROW_20_185 VGND VPWR sky130_fd_sc_hd__tapvpwrvgnd_1
XTAP_TAPCELL_ROW_20_186 VGND VPWR sky130_fd_sc_hd__tapvpwrvgnd_1
XTAP_TAPCELL_ROW_20_187 VGND VPWR sky130_fd_sc_hd__tapvpwrvgnd_1
XTAP_TAPCELL_ROW_20_188 VGND VPWR sky130_fd_sc_hd__tapvpwrvgnd_1
XTAP_TAPCELL_ROW_21_189 VGND VPWR sky130_fd_sc_hd__tapvpwrvgnd_1
XTAP_TAPCELL_ROW_21_190 VGND VPWR sky130_fd_sc_hd__tapvpwrvgnd_1
XTAP_TAPCELL_ROW_21_191 VGND VPWR sky130_fd_sc_hd__tapvpwrvgnd_1
XTAP_TAPCELL_ROW_21_192 VGND VPWR sky130_fd_sc_hd__tapvpwrvgnd_1
XTAP_TAPCELL_ROW_21_193 VGND VPWR sky130_fd_sc_hd__tapvpwrvgnd_1
XTAP_TAPCELL_ROW_22_194 VGND VPWR sky130_fd_sc_hd__tapvpwrvgnd_1
XTAP_TAPCELL_ROW_22_195 VGND VPWR sky130_fd_sc_hd__tapvpwrvgnd_1
XTAP_TAPCELL_ROW_22_196 VGND VPWR sky130_fd_sc_hd__tapvpwrvgnd_1
XTAP_TAPCELL_ROW_22_197 VGND VPWR sky130_fd_sc_hd__tapvpwrvgnd_1
XTAP_TAPCELL_ROW_22_198 VGND VPWR sky130_fd_sc_hd__tapvpwrvgnd_1
XTAP_TAPCELL_ROW_22_199 VGND VPWR sky130_fd_sc_hd__tapvpwrvgnd_1
XTAP_TAPCELL_ROW_23_200 VGND VPWR sky130_fd_sc_hd__tapvpwrvgnd_1
XTAP_TAPCELL_ROW_23_201 VGND VPWR sky130_fd_sc_hd__tapvpwrvgnd_1
XTAP_TAPCELL_ROW_23_202 VGND VPWR sky130_fd_sc_hd__tapvpwrvgnd_1
XTAP_TAPCELL_ROW_23_203 VGND VPWR sky130_fd_sc_hd__tapvpwrvgnd_1
XTAP_TAPCELL_ROW_23_204 VGND VPWR sky130_fd_sc_hd__tapvpwrvgnd_1
XTAP_TAPCELL_ROW_24_205 VGND VPWR sky130_fd_sc_hd__tapvpwrvgnd_1
XTAP_TAPCELL_ROW_24_206 VGND VPWR sky130_fd_sc_hd__tapvpwrvgnd_1
XTAP_TAPCELL_ROW_24_207 VGND VPWR sky130_fd_sc_hd__tapvpwrvgnd_1
XTAP_TAPCELL_ROW_24_208 VGND VPWR sky130_fd_sc_hd__tapvpwrvgnd_1
XTAP_TAPCELL_ROW_24_209 VGND VPWR sky130_fd_sc_hd__tapvpwrvgnd_1
XTAP_TAPCELL_ROW_24_210 VGND VPWR sky130_fd_sc_hd__tapvpwrvgnd_1
XTAP_TAPCELL_ROW_25_211 VGND VPWR sky130_fd_sc_hd__tapvpwrvgnd_1
XTAP_TAPCELL_ROW_25_212 VGND VPWR sky130_fd_sc_hd__tapvpwrvgnd_1
XTAP_TAPCELL_ROW_25_213 VGND VPWR sky130_fd_sc_hd__tapvpwrvgnd_1
XTAP_TAPCELL_ROW_25_214 VGND VPWR sky130_fd_sc_hd__tapvpwrvgnd_1
XTAP_TAPCELL_ROW_25_215 VGND VPWR sky130_fd_sc_hd__tapvpwrvgnd_1
XTAP_TAPCELL_ROW_26_216 VGND VPWR sky130_fd_sc_hd__tapvpwrvgnd_1
XTAP_TAPCELL_ROW_26_217 VGND VPWR sky130_fd_sc_hd__tapvpwrvgnd_1
XTAP_TAPCELL_ROW_26_218 VGND VPWR sky130_fd_sc_hd__tapvpwrvgnd_1
XTAP_TAPCELL_ROW_26_219 VGND VPWR sky130_fd_sc_hd__tapvpwrvgnd_1
XTAP_TAPCELL_ROW_26_220 VGND VPWR sky130_fd_sc_hd__tapvpwrvgnd_1
XTAP_TAPCELL_ROW_26_221 VGND VPWR sky130_fd_sc_hd__tapvpwrvgnd_1
XTAP_TAPCELL_ROW_27_222 VGND VPWR sky130_fd_sc_hd__tapvpwrvgnd_1
XTAP_TAPCELL_ROW_27_223 VGND VPWR sky130_fd_sc_hd__tapvpwrvgnd_1
XTAP_TAPCELL_ROW_27_224 VGND VPWR sky130_fd_sc_hd__tapvpwrvgnd_1
XTAP_TAPCELL_ROW_27_225 VGND VPWR sky130_fd_sc_hd__tapvpwrvgnd_1
XTAP_TAPCELL_ROW_27_226 VGND VPWR sky130_fd_sc_hd__tapvpwrvgnd_1
XTAP_TAPCELL_ROW_28_227 VGND VPWR sky130_fd_sc_hd__tapvpwrvgnd_1
XTAP_TAPCELL_ROW_28_228 VGND VPWR sky130_fd_sc_hd__tapvpwrvgnd_1
XTAP_TAPCELL_ROW_28_229 VGND VPWR sky130_fd_sc_hd__tapvpwrvgnd_1
XTAP_TAPCELL_ROW_28_230 VGND VPWR sky130_fd_sc_hd__tapvpwrvgnd_1
XTAP_TAPCELL_ROW_28_231 VGND VPWR sky130_fd_sc_hd__tapvpwrvgnd_1
XTAP_TAPCELL_ROW_28_232 VGND VPWR sky130_fd_sc_hd__tapvpwrvgnd_1
XTAP_TAPCELL_ROW_29_233 VGND VPWR sky130_fd_sc_hd__tapvpwrvgnd_1
XTAP_TAPCELL_ROW_29_234 VGND VPWR sky130_fd_sc_hd__tapvpwrvgnd_1
XTAP_TAPCELL_ROW_29_235 VGND VPWR sky130_fd_sc_hd__tapvpwrvgnd_1
XTAP_TAPCELL_ROW_29_236 VGND VPWR sky130_fd_sc_hd__tapvpwrvgnd_1
XTAP_TAPCELL_ROW_29_237 VGND VPWR sky130_fd_sc_hd__tapvpwrvgnd_1
XTAP_TAPCELL_ROW_30_238 VGND VPWR sky130_fd_sc_hd__tapvpwrvgnd_1
XTAP_TAPCELL_ROW_30_239 VGND VPWR sky130_fd_sc_hd__tapvpwrvgnd_1
XTAP_TAPCELL_ROW_30_240 VGND VPWR sky130_fd_sc_hd__tapvpwrvgnd_1
XTAP_TAPCELL_ROW_30_241 VGND VPWR sky130_fd_sc_hd__tapvpwrvgnd_1
XTAP_TAPCELL_ROW_30_242 VGND VPWR sky130_fd_sc_hd__tapvpwrvgnd_1
XTAP_TAPCELL_ROW_30_243 VGND VPWR sky130_fd_sc_hd__tapvpwrvgnd_1
XTAP_TAPCELL_ROW_31_244 VGND VPWR sky130_fd_sc_hd__tapvpwrvgnd_1
XTAP_TAPCELL_ROW_31_245 VGND VPWR sky130_fd_sc_hd__tapvpwrvgnd_1
XTAP_TAPCELL_ROW_31_246 VGND VPWR sky130_fd_sc_hd__tapvpwrvgnd_1
XTAP_TAPCELL_ROW_31_247 VGND VPWR sky130_fd_sc_hd__tapvpwrvgnd_1
XTAP_TAPCELL_ROW_31_248 VGND VPWR sky130_fd_sc_hd__tapvpwrvgnd_1
XTAP_TAPCELL_ROW_32_249 VGND VPWR sky130_fd_sc_hd__tapvpwrvgnd_1
XTAP_TAPCELL_ROW_32_250 VGND VPWR sky130_fd_sc_hd__tapvpwrvgnd_1
XTAP_TAPCELL_ROW_32_251 VGND VPWR sky130_fd_sc_hd__tapvpwrvgnd_1
XTAP_TAPCELL_ROW_32_252 VGND VPWR sky130_fd_sc_hd__tapvpwrvgnd_1
XTAP_TAPCELL_ROW_32_253 VGND VPWR sky130_fd_sc_hd__tapvpwrvgnd_1
XTAP_TAPCELL_ROW_32_254 VGND VPWR sky130_fd_sc_hd__tapvpwrvgnd_1
XTAP_TAPCELL_ROW_33_255 VGND VPWR sky130_fd_sc_hd__tapvpwrvgnd_1
XTAP_TAPCELL_ROW_33_256 VGND VPWR sky130_fd_sc_hd__tapvpwrvgnd_1
XTAP_TAPCELL_ROW_33_257 VGND VPWR sky130_fd_sc_hd__tapvpwrvgnd_1
XTAP_TAPCELL_ROW_33_258 VGND VPWR sky130_fd_sc_hd__tapvpwrvgnd_1
XTAP_TAPCELL_ROW_33_259 VGND VPWR sky130_fd_sc_hd__tapvpwrvgnd_1
XTAP_TAPCELL_ROW_33_260 VGND VPWR sky130_fd_sc_hd__tapvpwrvgnd_1
XTAP_TAPCELL_ROW_33_261 VGND VPWR sky130_fd_sc_hd__tapvpwrvgnd_1
XTAP_TAPCELL_ROW_33_262 VGND VPWR sky130_fd_sc_hd__tapvpwrvgnd_1
XTAP_TAPCELL_ROW_33_263 VGND VPWR sky130_fd_sc_hd__tapvpwrvgnd_1
XTAP_TAPCELL_ROW_33_264 VGND VPWR sky130_fd_sc_hd__tapvpwrvgnd_1
XTAP_TAPCELL_ROW_33_265 VGND VPWR sky130_fd_sc_hd__tapvpwrvgnd_1
Xmax_cap1 add1.bit_add[10].fa.b VGND VGND VPWR VPWR net1 sky130_fd_sc_hd__clkbuf_8
Xmax_cap2 cic_n VGND VGND VPWR VPWR net2 sky130_fd_sc_hd__clkbuf_8
Xmax_cap3 cic_n VGND VGND VPWR VPWR net3 sky130_fd_sc_hd__buf_6
Xadd1.bit_add[0].fa.fa_4 VGND VGND VPWR VPWR open_add1.bit_add[0].fa.fa_4_HI net4 sky130_fd_sc_hd__conb_1
Xadd2.bit_add[0].fa.fa_5 VGND VGND VPWR VPWR open_add2.bit_add[0].fa.fa_5_HI net5 sky130_fd_sc_hd__conb_1
X_494__7 VGND VGND VPWR VPWR net7 open__494__7_LO sky130_fd_sc_hd__conb_1
Xclkbuf_4_0_0_clk clknet_0_clk VGND VGND VPWR VPWR clknet_4_0_0_clk sky130_fd_sc_hd__clkbuf_4
Xclkbuf_4_1_0_clk clknet_0_clk VGND VGND VPWR VPWR clknet_4_1_0_clk sky130_fd_sc_hd__clkbuf_4
Xclkbuf_4_2_0_clk clknet_0_clk VGND VGND VPWR VPWR clknet_4_2_0_clk sky130_fd_sc_hd__clkbuf_4
Xclkbuf_4_3_0_clk clknet_0_clk VGND VGND VPWR VPWR clknet_4_3_0_clk sky130_fd_sc_hd__clkbuf_4
Xclkbuf_4_4_0_clk clknet_0_clk VGND VGND VPWR VPWR clknet_4_4_0_clk sky130_fd_sc_hd__clkbuf_4
Xclkbuf_4_5_0_clk clknet_0_clk VGND VGND VPWR VPWR clknet_4_5_0_clk sky130_fd_sc_hd__clkbuf_4
Xclkbuf_4_6_0_clk clknet_0_clk VGND VGND VPWR VPWR clknet_4_6_0_clk sky130_fd_sc_hd__clkbuf_4
Xclkbuf_4_7_0_clk clknet_0_clk VGND VGND VPWR VPWR clknet_4_7_0_clk sky130_fd_sc_hd__clkbuf_4
Xclkbuf_4_8_0_clk clknet_0_clk VGND VGND VPWR VPWR clknet_4_8_0_clk sky130_fd_sc_hd__clkbuf_4
Xclkbuf_4_9_0_clk clknet_0_clk VGND VGND VPWR VPWR clknet_4_9_0_clk sky130_fd_sc_hd__clkbuf_4
Xclkbuf_4_10_0_clk clknet_0_clk VGND VGND VPWR VPWR clknet_4_10_0_clk sky130_fd_sc_hd__clkbuf_4
Xclkbuf_4_11_0_clk clknet_0_clk VGND VGND VPWR VPWR clknet_4_11_0_clk sky130_fd_sc_hd__clkbuf_4
Xclkbuf_4_12_0_clk clknet_0_clk VGND VGND VPWR VPWR clknet_4_12_0_clk sky130_fd_sc_hd__clkbuf_4
Xclkbuf_4_13_0_clk clknet_0_clk VGND VGND VPWR VPWR clknet_4_13_0_clk sky130_fd_sc_hd__clkbuf_4
Xclkbuf_4_14_0_clk clknet_0_clk VGND VGND VPWR VPWR clknet_4_14_0_clk sky130_fd_sc_hd__clkbuf_4
Xclkbuf_4_15_0_clk clknet_0_clk VGND VGND VPWR VPWR clknet_4_15_0_clk sky130_fd_sc_hd__clkbuf_4
Xclkbuf_0_g_work.gclk g_work.gclk VGND VGND VPWR VPWR clknet_0_g_work.gclk sky130_fd_sc_hd__clkbuf_4
Xclkbuf_1_0__f_g_work.gclk clknet_0_g_work.gclk VGND VGND VPWR VPWR clknet_1_0__leaf_g_work.gclk sky130_fd_sc_hd__clkbuf_4
Xclkbuf_1_1__f_g_work.gclk clknet_0_g_work.gclk VGND VGND VPWR VPWR clknet_1_1__leaf_g_work.gclk sky130_fd_sc_hd__clkbuf_4
Xclkbuf_0_g_delay.gclk g_delay.gclk VGND VGND VPWR VPWR clknet_0_g_delay.gclk sky130_fd_sc_hd__clkbuf_4
Xclkbuf_2_0__f_g_delay.gclk clknet_0_g_delay.gclk VGND VGND VPWR VPWR clknet_2_0__leaf_g_delay.gclk sky130_fd_sc_hd__clkbuf_4
Xclkbuf_2_1__f_g_delay.gclk clknet_0_g_delay.gclk VGND VGND VPWR VPWR clknet_2_1__leaf_g_delay.gclk sky130_fd_sc_hd__clkbuf_4
Xclkbuf_2_2__f_g_delay.gclk clknet_0_g_delay.gclk VGND VGND VPWR VPWR clknet_2_2__leaf_g_delay.gclk sky130_fd_sc_hd__clkbuf_4
Xclkbuf_2_3__f_g_delay.gclk clknet_0_g_delay.gclk VGND VGND VPWR VPWR clknet_2_3__leaf_g_delay.gclk sky130_fd_sc_hd__clkbuf_4
Xclkbuf_0_tap_p[0] tap_p[0] VGND VGND VPWR VPWR clknet_0_tap_p[0] sky130_fd_sc_hd__clkbuf_4
Xclkbuf_1_0__f_tap_p[0] clknet_0_tap_p[0] VGND VGND VPWR VPWR clknet_1_0__leaf_tap_p[0] sky130_fd_sc_hd__clkbuf_4
Xclkbuf_1_1__f_tap_p[0] clknet_0_tap_p[0] VGND VGND VPWR VPWR clknet_1_1__leaf_tap_p[0] sky130_fd_sc_hd__clkbuf_4
Xclkbuf_0_vp.cg.gclk vp.cg.gclk VGND VGND VPWR VPWR clknet_0_vp.cg.gclk sky130_fd_sc_hd__clkbuf_4
Xclkbuf_1_0__f_vp.cg.gclk clknet_0_vp.cg.gclk VGND VGND VPWR VPWR clknet_1_0__leaf_vp.cg.gclk sky130_fd_sc_hd__clkbuf_4
Xclkbuf_1_1__f_vp.cg.gclk clknet_0_vp.cg.gclk VGND VGND VPWR VPWR clknet_1_1__leaf_vp.cg.gclk sky130_fd_sc_hd__clkbuf_4
Xclkbuf_0_tap_n[0] tap_n[0] VGND VGND VPWR VPWR clknet_0_tap_n[0] sky130_fd_sc_hd__clkbuf_4
Xclkbuf_1_0__f_tap_n[0] clknet_0_tap_n[0] VGND VGND VPWR VPWR clknet_1_0__leaf_tap_n[0] sky130_fd_sc_hd__clkbuf_4
Xclkbuf_1_1__f_tap_n[0] clknet_0_tap_n[0] VGND VGND VPWR VPWR clknet_1_1__leaf_tap_n[0] sky130_fd_sc_hd__clkbuf_4
Xclkbuf_0_vn.cg.gclk vn.cg.gclk VGND VGND VPWR VPWR clknet_0_vn.cg.gclk sky130_fd_sc_hd__clkbuf_4
Xclkbuf_1_0__f_vn.cg.gclk clknet_0_vn.cg.gclk VGND VGND VPWR VPWR clknet_1_0__leaf_vn.cg.gclk sky130_fd_sc_hd__clkbuf_4
Xclkbuf_1_1__f_vn.cg.gclk clknet_0_vn.cg.gclk VGND VGND VPWR VPWR clknet_1_1__leaf_vn.cg.gclk sky130_fd_sc_hd__clkbuf_4
Xhold1 add2.bit_add[19].fa.a VGND VGND VPWR VPWR net8 sky130_fd_sc_hd__dlygate4sd3_1
Xhold2 add2.bit_add[13].fa.a VGND VGND VPWR VPWR net9 sky130_fd_sc_hd__dlygate4sd3_1
Xhold3 add2.bit_add[14].fa.a VGND VGND VPWR VPWR net10 sky130_fd_sc_hd__dlygate4sd3_1
Xhold4 add2.bit_add[4].fa.a VGND VGND VPWR VPWR net11 sky130_fd_sc_hd__dlygate4sd3_1
Xhold5 add2.bit_add[1].fa.a VGND VGND VPWR VPWR net12 sky130_fd_sc_hd__dlygate4sd3_1
Xhold6 add2.bit_add[15].fa.a VGND VGND VPWR VPWR net13 sky130_fd_sc_hd__dlygate4sd3_1
Xhold7 add2.bit_add[3].fa.a VGND VGND VPWR VPWR net14 sky130_fd_sc_hd__dlygate4sd3_1
Xhold8 add2.bit_add[18].fa.a VGND VGND VPWR VPWR net15 sky130_fd_sc_hd__dlygate4sd3_1
Xhold9 add2.bit_add[17].fa.a VGND VGND VPWR VPWR net16 sky130_fd_sc_hd__dlygate4sd3_1
Xhold10 add2.bit_add[2].fa.a VGND VGND VPWR VPWR net17 sky130_fd_sc_hd__dlygate4sd3_1
Xhold11 add2.bit_add[20].fa.a VGND VGND VPWR VPWR net18 sky130_fd_sc_hd__dlygate4sd3_1
Xhold12 add2.bit_add[16].fa.a VGND VGND VPWR VPWR net19 sky130_fd_sc_hd__dlygate4sd3_1
Xhold13 add2.bit_add[11].fa.a VGND VGND VPWR VPWR net20 sky130_fd_sc_hd__dlygate4sd3_1
Xhold14 add2.bit_add[10].fa.a VGND VGND VPWR VPWR net21 sky130_fd_sc_hd__dlygate4sd3_1
Xhold15 add2.bit_add[8].fa.a VGND VGND VPWR VPWR net22 sky130_fd_sc_hd__dlygate4sd3_1
Xhold16 add2.bit_add[12].fa.a VGND VGND VPWR VPWR net23 sky130_fd_sc_hd__dlygate4sd3_1
Xhold17 add2.bit_add[9].fa.a VGND VGND VPWR VPWR net24 sky130_fd_sc_hd__dlygate4sd3_1
Xhold18 add2.bit_add[0].fa.a VGND VGND VPWR VPWR net25 sky130_fd_sc_hd__dlygate4sd3_1
Xhold19 add2.bit_add[7].fa.a VGND VGND VPWR VPWR net26 sky130_fd_sc_hd__dlygate4sd3_1
Xhold20 add2.bit_add[5].fa.a VGND VGND VPWR VPWR net27 sky130_fd_sc_hd__dlygate4sd3_1
Xhold21 add2.bit_add[6].fa.a VGND VGND VPWR VPWR net28 sky130_fd_sc_hd__dlygate4sd3_1
Xhold22 borrow2 VGND VGND VPWR VPWR net29 sky130_fd_sc_hd__dlygate4sd3_1
Xhold23 borrow1 VGND VGND VPWR VPWR net30 sky130_fd_sc_hd__clkdlybuf4s25_1
XANTENNA_clkbuf_0_clk_A clk VGND VGND VPWR VPWR sky130_fd_sc_hd__diode_2
XANTENNA__218__A dbg_mode[0] VGND VGND VPWR VPWR sky130_fd_sc_hd__diode_2
XANTENNA__200__SLEEP dbg_mode[0] VGND VGND VPWR VPWR sky130_fd_sc_hd__diode_2
XANTENNA__220__A dbg_mode[1] VGND VGND VPWR VPWR sky130_fd_sc_hd__diode_2
XANTENNA__219__A dbg_mode[1] VGND VGND VPWR VPWR sky130_fd_sc_hd__diode_2
XANTENNA__200__A dbg_mode[1] VGND VGND VPWR VPWR sky130_fd_sc_hd__diode_2
XANTENNA__490__D err_clr VGND VGND VPWR VPWR sky130_fd_sc_hd__diode_2
XANTENNA__492__D osr_sel VGND VGND VPWR VPWR sky130_fd_sc_hd__diode_2
XANTENNA__507__RESET_B rst_n VGND VGND VPWR VPWR sky130_fd_sc_hd__diode_2
XANTENNA__506__RESET_B rst_n VGND VGND VPWR VPWR sky130_fd_sc_hd__diode_2
XANTENNA__505__RESET_B rst_n VGND VGND VPWR VPWR sky130_fd_sc_hd__diode_2
XANTENNA__504__RESET_B rst_n VGND VGND VPWR VPWR sky130_fd_sc_hd__diode_2
XANTENNA__503__RESET_B rst_n VGND VGND VPWR VPWR sky130_fd_sc_hd__diode_2
XANTENNA__502__RESET_B rst_n VGND VGND VPWR VPWR sky130_fd_sc_hd__diode_2
XANTENNA__501__RESET_B rst_n VGND VGND VPWR VPWR sky130_fd_sc_hd__diode_2
XANTENNA__500__RESET_B rst_n VGND VGND VPWR VPWR sky130_fd_sc_hd__diode_2
XANTENNA__499__RESET_B rst_n VGND VGND VPWR VPWR sky130_fd_sc_hd__diode_2
XANTENNA__498__RESET_B rst_n VGND VGND VPWR VPWR sky130_fd_sc_hd__diode_2
XANTENNA__497__RESET_B rst_n VGND VGND VPWR VPWR sky130_fd_sc_hd__diode_2
XANTENNA__496__RESET_B rst_n VGND VGND VPWR VPWR sky130_fd_sc_hd__diode_2
XANTENNA__495__RESET_B rst_n VGND VGND VPWR VPWR sky130_fd_sc_hd__diode_2
XANTENNA__494__RESET_B rst_n VGND VGND VPWR VPWR sky130_fd_sc_hd__diode_2
XANTENNA_clkbuf_0_tap_n[0]_A tap_n[0] VGND VGND VPWR VPWR sky130_fd_sc_hd__diode_2
XANTENNA__410__D tap_n[10] VGND VGND VPWR VPWR sky130_fd_sc_hd__diode_2
XANTENNA__411__D tap_n[11] VGND VGND VPWR VPWR sky130_fd_sc_hd__diode_2
XANTENNA__412__D tap_n[12] VGND VGND VPWR VPWR sky130_fd_sc_hd__diode_2
XANTENNA__413__D tap_n[13] VGND VGND VPWR VPWR sky130_fd_sc_hd__diode_2
XANTENNA__414__D tap_n[14] VGND VGND VPWR VPWR sky130_fd_sc_hd__diode_2
XANTENNA__401__D tap_n[1] VGND VGND VPWR VPWR sky130_fd_sc_hd__diode_2
XANTENNA__402__D tap_n[2] VGND VGND VPWR VPWR sky130_fd_sc_hd__diode_2
XANTENNA__403__D tap_n[3] VGND VGND VPWR VPWR sky130_fd_sc_hd__diode_2
XANTENNA__404__D tap_n[4] VGND VGND VPWR VPWR sky130_fd_sc_hd__diode_2
XANTENNA__405__D tap_n[5] VGND VGND VPWR VPWR sky130_fd_sc_hd__diode_2
XANTENNA__406__D tap_n[6] VGND VGND VPWR VPWR sky130_fd_sc_hd__diode_2
XANTENNA__407__D tap_n[7] VGND VGND VPWR VPWR sky130_fd_sc_hd__diode_2
XANTENNA__408__D tap_n[8] VGND VGND VPWR VPWR sky130_fd_sc_hd__diode_2
XANTENNA__409__D tap_n[9] VGND VGND VPWR VPWR sky130_fd_sc_hd__diode_2
XANTENNA_clkbuf_0_tap_p[0]_A tap_p[0] VGND VGND VPWR VPWR sky130_fd_sc_hd__diode_2
XANTENNA__425__D tap_p[10] VGND VGND VPWR VPWR sky130_fd_sc_hd__diode_2
XANTENNA__426__D tap_p[11] VGND VGND VPWR VPWR sky130_fd_sc_hd__diode_2
XANTENNA__427__D tap_p[12] VGND VGND VPWR VPWR sky130_fd_sc_hd__diode_2
XANTENNA__428__D tap_p[13] VGND VGND VPWR VPWR sky130_fd_sc_hd__diode_2
XANTENNA__429__D tap_p[14] VGND VGND VPWR VPWR sky130_fd_sc_hd__diode_2
XANTENNA__416__D tap_p[1] VGND VGND VPWR VPWR sky130_fd_sc_hd__diode_2
XANTENNA__417__D tap_p[2] VGND VGND VPWR VPWR sky130_fd_sc_hd__diode_2
XANTENNA__418__D tap_p[3] VGND VGND VPWR VPWR sky130_fd_sc_hd__diode_2
XANTENNA__419__D tap_p[4] VGND VGND VPWR VPWR sky130_fd_sc_hd__diode_2
XANTENNA__420__D tap_p[5] VGND VGND VPWR VPWR sky130_fd_sc_hd__diode_2
XANTENNA__421__D tap_p[6] VGND VGND VPWR VPWR sky130_fd_sc_hd__diode_2
XANTENNA__422__D tap_p[7] VGND VGND VPWR VPWR sky130_fd_sc_hd__diode_2
XANTENNA__423__D tap_p[8] VGND VGND VPWR VPWR sky130_fd_sc_hd__diode_2
XANTENNA__424__D tap_p[9] VGND VGND VPWR VPWR sky130_fd_sc_hd__diode_2
XFILLER_0_0_3 VGND VGND VPWR VPWR sky130_fd_sc_hd__decap_3
XFILLER_0_0_6 VGND VGND VPWR VPWR sky130_fd_sc_hd__decap_3
XFILLER_0_0_9 VGND VGND VPWR VPWR sky130_fd_sc_hd__decap_3
XFILLER_0_0_12 VGND VGND VPWR VPWR sky130_fd_sc_hd__decap_3
XFILLER_0_0_15 VGND VGND VPWR VPWR sky130_fd_sc_hd__decap_3
XFILLER_0_0_18 VGND VGND VPWR VPWR sky130_fd_sc_hd__decap_3
XFILLER_0_0_21 VGND VGND VPWR VPWR sky130_fd_sc_hd__decap_3
XFILLER_0_0_26 VGND VGND VPWR VPWR sky130_fd_sc_hd__fill_2
XFILLER_0_0_29 VGND VGND VPWR VPWR sky130_fd_sc_hd__decap_3
XFILLER_0_0_32 VGND VGND VPWR VPWR sky130_fd_sc_hd__decap_3
XFILLER_0_0_35 VGND VGND VPWR VPWR sky130_fd_sc_hd__decap_3
XFILLER_0_0_57 VGND VGND VPWR VPWR sky130_fd_sc_hd__fill_2
XFILLER_0_0_61 VGND VGND VPWR VPWR sky130_fd_sc_hd__decap_3
XFILLER_0_0_64 VGND VGND VPWR VPWR sky130_fd_sc_hd__fill_2
XFILLER_0_0_85 VGND VGND VPWR VPWR sky130_fd_sc_hd__decap_3
XFILLER_0_0_104 VGND VGND VPWR VPWR sky130_fd_sc_hd__decap_3
XFILLER_0_0_107 VGND VGND VPWR VPWR sky130_fd_sc_hd__decap_3
XFILLER_0_0_110 VGND VGND VPWR VPWR sky130_fd_sc_hd__fill_2
XFILLER_0_0_113 VGND VGND VPWR VPWR sky130_fd_sc_hd__decap_3
XFILLER_0_0_116 VGND VGND VPWR VPWR sky130_fd_sc_hd__decap_3
XFILLER_0_0_119 VGND VGND VPWR VPWR sky130_fd_sc_hd__fill_2
XFILLER_0_0_137 VGND VGND VPWR VPWR sky130_fd_sc_hd__decap_3
XFILLER_0_0_141 VGND VGND VPWR VPWR sky130_fd_sc_hd__fill_2
XFILLER_0_0_145 VGND VGND VPWR VPWR sky130_fd_sc_hd__decap_3
XFILLER_0_0_148 VGND VGND VPWR VPWR sky130_fd_sc_hd__fill_1
XFILLER_0_0_167 VGND VGND VPWR VPWR sky130_fd_sc_hd__fill_1
XFILLER_0_0_169 VGND VGND VPWR VPWR sky130_fd_sc_hd__fill_2
XFILLER_0_0_173 VGND VGND VPWR VPWR sky130_fd_sc_hd__decap_3
XFILLER_0_0_176 VGND VGND VPWR VPWR sky130_fd_sc_hd__decap_3
XFILLER_0_0_179 VGND VGND VPWR VPWR sky130_fd_sc_hd__decap_3
XFILLER_0_0_182 VGND VGND VPWR VPWR sky130_fd_sc_hd__decap_3
XFILLER_0_0_187 VGND VGND VPWR VPWR sky130_fd_sc_hd__decap_3
XFILLER_0_0_190 VGND VGND VPWR VPWR sky130_fd_sc_hd__decap_3
XFILLER_0_0_193 VGND VGND VPWR VPWR sky130_fd_sc_hd__decap_3
XFILLER_0_0_213 VGND VGND VPWR VPWR sky130_fd_sc_hd__fill_2
XFILLER_0_0_217 VGND VGND VPWR VPWR sky130_fd_sc_hd__decap_3
XFILLER_0_0_220 VGND VGND VPWR VPWR sky130_fd_sc_hd__fill_2
XFILLER_0_0_241 VGND VGND VPWR VPWR sky130_fd_sc_hd__fill_2
XFILLER_0_0_245 VGND VGND VPWR VPWR sky130_fd_sc_hd__decap_3
XFILLER_0_0_248 VGND VGND VPWR VPWR sky130_fd_sc_hd__decap_3
XFILLER_0_0_251 VGND VGND VPWR VPWR sky130_fd_sc_hd__fill_1
XFILLER_0_0_269 VGND VGND VPWR VPWR sky130_fd_sc_hd__fill_2
XFILLER_0_0_273 VGND VGND VPWR VPWR sky130_fd_sc_hd__decap_3
XFILLER_0_0_276 VGND VGND VPWR VPWR sky130_fd_sc_hd__decap_3
XFILLER_0_0_279 VGND VGND VPWR VPWR sky130_fd_sc_hd__fill_1
XFILLER_0_0_281 VGND VGND VPWR VPWR sky130_fd_sc_hd__decap_3
XFILLER_0_0_284 VGND VGND VPWR VPWR sky130_fd_sc_hd__decap_3
XFILLER_0_0_287 VGND VGND VPWR VPWR sky130_fd_sc_hd__decap_3
XFILLER_0_0_290 VGND VGND VPWR VPWR sky130_fd_sc_hd__fill_2
XFILLER_0_0_309 VGND VGND VPWR VPWR sky130_fd_sc_hd__decap_3
XFILLER_0_0_312 VGND VGND VPWR VPWR sky130_fd_sc_hd__decap_3
XFILLER_0_0_315 VGND VGND VPWR VPWR sky130_fd_sc_hd__fill_2
XFILLER_0_1_3 VGND VGND VPWR VPWR sky130_fd_sc_hd__decap_3
XFILLER_0_1_6 VGND VGND VPWR VPWR sky130_fd_sc_hd__fill_2
XFILLER_0_1_57 VGND VGND VPWR VPWR sky130_fd_sc_hd__decap_3
XFILLER_0_1_60 VGND VGND VPWR VPWR sky130_fd_sc_hd__fill_1
XFILLER_0_1_63 VGND VGND VPWR VPWR sky130_fd_sc_hd__fill_1
XFILLER_0_1_113 VGND VGND VPWR VPWR sky130_fd_sc_hd__fill_2
XFILLER_0_1_117 VGND VGND VPWR VPWR sky130_fd_sc_hd__fill_2
XFILLER_0_1_167 VGND VGND VPWR VPWR sky130_fd_sc_hd__fill_1
XFILLER_0_1_169 VGND VGND VPWR VPWR sky130_fd_sc_hd__fill_2
XFILLER_0_1_219 VGND VGND VPWR VPWR sky130_fd_sc_hd__decap_3
XFILLER_0_1_273 VGND VGND VPWR VPWR sky130_fd_sc_hd__decap_3
XFILLER_0_1_276 VGND VGND VPWR VPWR sky130_fd_sc_hd__fill_2
XFILLER_0_1_313 VGND VGND VPWR VPWR sky130_fd_sc_hd__decap_3
XFILLER_0_1_316 VGND VGND VPWR VPWR sky130_fd_sc_hd__fill_1
XFILLER_0_2_3 VGND VGND VPWR VPWR sky130_fd_sc_hd__decap_3
XFILLER_0_2_6 VGND VGND VPWR VPWR sky130_fd_sc_hd__decap_3
XFILLER_0_2_9 VGND VGND VPWR VPWR sky130_fd_sc_hd__decap_3
XFILLER_0_2_12 VGND VGND VPWR VPWR sky130_fd_sc_hd__decap_3
XFILLER_0_2_15 VGND VGND VPWR VPWR sky130_fd_sc_hd__decap_3
XFILLER_0_2_18 VGND VGND VPWR VPWR sky130_fd_sc_hd__decap_3
XFILLER_0_2_21 VGND VGND VPWR VPWR sky130_fd_sc_hd__decap_3
XFILLER_0_2_24 VGND VGND VPWR VPWR sky130_fd_sc_hd__decap_3
XFILLER_0_2_27 VGND VGND VPWR VPWR sky130_fd_sc_hd__fill_1
XFILLER_0_2_29 VGND VGND VPWR VPWR sky130_fd_sc_hd__decap_3
XFILLER_0_2_32 VGND VGND VPWR VPWR sky130_fd_sc_hd__decap_3
XFILLER_0_2_35 VGND VGND VPWR VPWR sky130_fd_sc_hd__decap_3
XFILLER_0_2_38 VGND VGND VPWR VPWR sky130_fd_sc_hd__fill_2
XFILLER_0_2_42 VGND VGND VPWR VPWR sky130_fd_sc_hd__decap_3
XFILLER_0_2_77 VGND VGND VPWR VPWR sky130_fd_sc_hd__decap_3
XFILLER_0_2_82 VGND VGND VPWR VPWR sky130_fd_sc_hd__fill_2
XFILLER_0_2_85 VGND VGND VPWR VPWR sky130_fd_sc_hd__decap_3
XFILLER_0_2_88 VGND VGND VPWR VPWR sky130_fd_sc_hd__fill_2
XFILLER_0_2_141 VGND VGND VPWR VPWR sky130_fd_sc_hd__fill_2
XFILLER_0_2_145 VGND VGND VPWR VPWR sky130_fd_sc_hd__fill_2
XFILLER_0_2_179 VGND VGND VPWR VPWR sky130_fd_sc_hd__decap_3
XFILLER_0_2_182 VGND VGND VPWR VPWR sky130_fd_sc_hd__decap_3
XFILLER_0_2_185 VGND VGND VPWR VPWR sky130_fd_sc_hd__fill_2
XFILLER_0_2_189 VGND VGND VPWR VPWR sky130_fd_sc_hd__decap_3
XFILLER_0_2_192 VGND VGND VPWR VPWR sky130_fd_sc_hd__decap_3
XFILLER_0_2_195 VGND VGND VPWR VPWR sky130_fd_sc_hd__fill_1
XFILLER_0_2_197 VGND VGND VPWR VPWR sky130_fd_sc_hd__decap_3
XFILLER_0_2_200 VGND VGND VPWR VPWR sky130_fd_sc_hd__fill_1
XFILLER_0_2_203 VGND VGND VPWR VPWR sky130_fd_sc_hd__fill_1
XFILLER_0_2_253 VGND VGND VPWR VPWR sky130_fd_sc_hd__fill_2
XFILLER_0_2_257 VGND VGND VPWR VPWR sky130_fd_sc_hd__decap_3
XFILLER_0_2_309 VGND VGND VPWR VPWR sky130_fd_sc_hd__decap_3
XFILLER_0_2_312 VGND VGND VPWR VPWR sky130_fd_sc_hd__decap_3
XFILLER_0_2_315 VGND VGND VPWR VPWR sky130_fd_sc_hd__fill_2
XFILLER_0_3_3 VGND VGND VPWR VPWR sky130_fd_sc_hd__decap_3
XFILLER_0_3_6 VGND VGND VPWR VPWR sky130_fd_sc_hd__decap_3
XFILLER_0_3_9 VGND VGND VPWR VPWR sky130_fd_sc_hd__decap_3
XFILLER_0_3_12 VGND VGND VPWR VPWR sky130_fd_sc_hd__decap_3
XFILLER_0_3_15 VGND VGND VPWR VPWR sky130_fd_sc_hd__decap_3
XFILLER_0_3_18 VGND VGND VPWR VPWR sky130_fd_sc_hd__decap_3
XFILLER_0_3_21 VGND VGND VPWR VPWR sky130_fd_sc_hd__decap_3
XFILLER_0_3_24 VGND VGND VPWR VPWR sky130_fd_sc_hd__decap_3
XFILLER_0_3_27 VGND VGND VPWR VPWR sky130_fd_sc_hd__decap_3
XFILLER_0_3_30 VGND VGND VPWR VPWR sky130_fd_sc_hd__decap_3
XFILLER_0_3_33 VGND VGND VPWR VPWR sky130_fd_sc_hd__fill_2
XFILLER_0_3_51 VGND VGND VPWR VPWR sky130_fd_sc_hd__decap_3
XFILLER_0_3_54 VGND VGND VPWR VPWR sky130_fd_sc_hd__fill_2
XFILLER_0_3_57 VGND VGND VPWR VPWR sky130_fd_sc_hd__decap_3
XFILLER_0_3_60 VGND VGND VPWR VPWR sky130_fd_sc_hd__decap_3
XFILLER_0_3_63 VGND VGND VPWR VPWR sky130_fd_sc_hd__fill_1
XFILLER_0_3_113 VGND VGND VPWR VPWR sky130_fd_sc_hd__fill_2
XFILLER_0_3_147 VGND VGND VPWR VPWR sky130_fd_sc_hd__decap_3
XFILLER_0_3_150 VGND VGND VPWR VPWR sky130_fd_sc_hd__decap_3
XFILLER_0_3_153 VGND VGND VPWR VPWR sky130_fd_sc_hd__decap_3
XFILLER_0_3_156 VGND VGND VPWR VPWR sky130_fd_sc_hd__decap_3
XFILLER_0_3_159 VGND VGND VPWR VPWR sky130_fd_sc_hd__decap_3
XFILLER_0_3_162 VGND VGND VPWR VPWR sky130_fd_sc_hd__decap_3
XFILLER_0_3_165 VGND VGND VPWR VPWR sky130_fd_sc_hd__decap_3
XFILLER_0_3_169 VGND VGND VPWR VPWR sky130_fd_sc_hd__decap_3
XFILLER_0_3_172 VGND VGND VPWR VPWR sky130_fd_sc_hd__decap_3
XFILLER_0_3_175 VGND VGND VPWR VPWR sky130_fd_sc_hd__decap_3
XFILLER_0_3_178 VGND VGND VPWR VPWR sky130_fd_sc_hd__decap_3
XFILLER_0_3_181 VGND VGND VPWR VPWR sky130_fd_sc_hd__decap_3
XFILLER_0_3_184 VGND VGND VPWR VPWR sky130_fd_sc_hd__decap_3
XFILLER_0_3_187 VGND VGND VPWR VPWR sky130_fd_sc_hd__decap_3
XFILLER_0_3_190 VGND VGND VPWR VPWR sky130_fd_sc_hd__decap_3
XFILLER_0_3_193 VGND VGND VPWR VPWR sky130_fd_sc_hd__decap_3
XFILLER_0_3_196 VGND VGND VPWR VPWR sky130_fd_sc_hd__fill_1
XFILLER_0_3_213 VGND VGND VPWR VPWR sky130_fd_sc_hd__decap_3
XFILLER_0_3_216 VGND VGND VPWR VPWR sky130_fd_sc_hd__decap_3
XFILLER_0_3_219 VGND VGND VPWR VPWR sky130_fd_sc_hd__decap_3
XFILLER_0_3_222 VGND VGND VPWR VPWR sky130_fd_sc_hd__fill_2
XFILLER_0_3_232 VGND VGND VPWR VPWR sky130_fd_sc_hd__decap_3
XFILLER_0_3_235 VGND VGND VPWR VPWR sky130_fd_sc_hd__fill_2
XFILLER_0_3_269 VGND VGND VPWR VPWR sky130_fd_sc_hd__decap_3
XFILLER_0_3_272 VGND VGND VPWR VPWR sky130_fd_sc_hd__fill_2
XFILLER_0_3_276 VGND VGND VPWR VPWR sky130_fd_sc_hd__decap_3
XFILLER_0_3_279 VGND VGND VPWR VPWR sky130_fd_sc_hd__fill_1
XFILLER_0_3_281 VGND VGND VPWR VPWR sky130_fd_sc_hd__decap_3
XFILLER_0_3_284 VGND VGND VPWR VPWR sky130_fd_sc_hd__decap_3
XFILLER_0_3_287 VGND VGND VPWR VPWR sky130_fd_sc_hd__decap_3
XFILLER_0_3_290 VGND VGND VPWR VPWR sky130_fd_sc_hd__fill_2
XFILLER_0_3_308 VGND VGND VPWR VPWR sky130_fd_sc_hd__decap_3
XFILLER_0_3_311 VGND VGND VPWR VPWR sky130_fd_sc_hd__decap_3
XFILLER_0_3_314 VGND VGND VPWR VPWR sky130_fd_sc_hd__decap_3
XFILLER_0_4_9 VGND VGND VPWR VPWR sky130_fd_sc_hd__decap_3
XFILLER_0_4_12 VGND VGND VPWR VPWR sky130_fd_sc_hd__decap_3
XFILLER_0_4_15 VGND VGND VPWR VPWR sky130_fd_sc_hd__decap_3
XFILLER_0_4_18 VGND VGND VPWR VPWR sky130_fd_sc_hd__decap_3
XFILLER_0_4_21 VGND VGND VPWR VPWR sky130_fd_sc_hd__decap_3
XFILLER_0_4_24 VGND VGND VPWR VPWR sky130_fd_sc_hd__decap_3
XFILLER_0_4_27 VGND VGND VPWR VPWR sky130_fd_sc_hd__fill_1
XFILLER_0_4_29 VGND VGND VPWR VPWR sky130_fd_sc_hd__fill_1
XFILLER_0_4_46 VGND VGND VPWR VPWR sky130_fd_sc_hd__fill_1
XFILLER_0_4_70 VGND VGND VPWR VPWR sky130_fd_sc_hd__decap_3
XFILLER_0_4_73 VGND VGND VPWR VPWR sky130_fd_sc_hd__decap_3
XFILLER_0_4_76 VGND VGND VPWR VPWR sky130_fd_sc_hd__decap_3
XFILLER_0_4_79 VGND VGND VPWR VPWR sky130_fd_sc_hd__decap_3
XFILLER_0_4_82 VGND VGND VPWR VPWR sky130_fd_sc_hd__fill_2
XFILLER_0_4_85 VGND VGND VPWR VPWR sky130_fd_sc_hd__fill_1
XFILLER_0_4_125 VGND VGND VPWR VPWR sky130_fd_sc_hd__decap_3
XFILLER_0_4_128 VGND VGND VPWR VPWR sky130_fd_sc_hd__decap_3
XFILLER_0_4_133 VGND VGND VPWR VPWR sky130_fd_sc_hd__decap_3
XFILLER_0_4_136 VGND VGND VPWR VPWR sky130_fd_sc_hd__decap_3
XFILLER_0_4_139 VGND VGND VPWR VPWR sky130_fd_sc_hd__fill_1
XFILLER_0_4_157 VGND VGND VPWR VPWR sky130_fd_sc_hd__decap_3
XFILLER_0_4_160 VGND VGND VPWR VPWR sky130_fd_sc_hd__decap_3
XFILLER_0_4_163 VGND VGND VPWR VPWR sky130_fd_sc_hd__fill_1
XFILLER_0_4_187 VGND VGND VPWR VPWR sky130_fd_sc_hd__decap_3
XFILLER_0_4_190 VGND VGND VPWR VPWR sky130_fd_sc_hd__decap_3
XFILLER_0_4_193 VGND VGND VPWR VPWR sky130_fd_sc_hd__decap_3
XFILLER_0_4_197 VGND VGND VPWR VPWR sky130_fd_sc_hd__decap_3
XFILLER_0_4_200 VGND VGND VPWR VPWR sky130_fd_sc_hd__decap_3
XFILLER_0_4_203 VGND VGND VPWR VPWR sky130_fd_sc_hd__decap_3
XFILLER_0_4_206 VGND VGND VPWR VPWR sky130_fd_sc_hd__decap_3
XFILLER_0_4_232 VGND VGND VPWR VPWR sky130_fd_sc_hd__decap_3
XFILLER_0_4_235 VGND VGND VPWR VPWR sky130_fd_sc_hd__decap_3
XFILLER_0_4_238 VGND VGND VPWR VPWR sky130_fd_sc_hd__decap_3
XFILLER_0_4_241 VGND VGND VPWR VPWR sky130_fd_sc_hd__decap_3
XFILLER_0_4_244 VGND VGND VPWR VPWR sky130_fd_sc_hd__fill_1
XFILLER_0_4_301 VGND VGND VPWR VPWR sky130_fd_sc_hd__decap_3
XFILLER_0_4_304 VGND VGND VPWR VPWR sky130_fd_sc_hd__decap_3
XFILLER_0_4_307 VGND VGND VPWR VPWR sky130_fd_sc_hd__fill_1
XFILLER_0_4_309 VGND VGND VPWR VPWR sky130_fd_sc_hd__decap_3
XFILLER_0_4_312 VGND VGND VPWR VPWR sky130_fd_sc_hd__decap_3
XFILLER_0_4_315 VGND VGND VPWR VPWR sky130_fd_sc_hd__fill_2
XFILLER_0_5_3 VGND VGND VPWR VPWR sky130_fd_sc_hd__decap_3
XFILLER_0_5_6 VGND VGND VPWR VPWR sky130_fd_sc_hd__decap_3
XFILLER_0_5_9 VGND VGND VPWR VPWR sky130_fd_sc_hd__decap_3
XFILLER_0_5_12 VGND VGND VPWR VPWR sky130_fd_sc_hd__decap_3
XFILLER_0_5_15 VGND VGND VPWR VPWR sky130_fd_sc_hd__decap_3
XFILLER_0_5_18 VGND VGND VPWR VPWR sky130_fd_sc_hd__decap_3
XFILLER_0_5_21 VGND VGND VPWR VPWR sky130_fd_sc_hd__decap_3
XFILLER_0_5_24 VGND VGND VPWR VPWR sky130_fd_sc_hd__decap_3
XFILLER_0_5_27 VGND VGND VPWR VPWR sky130_fd_sc_hd__decap_3
XFILLER_0_5_30 VGND VGND VPWR VPWR sky130_fd_sc_hd__decap_3
XFILLER_0_5_73 VGND VGND VPWR VPWR sky130_fd_sc_hd__fill_2
XFILLER_0_5_113 VGND VGND VPWR VPWR sky130_fd_sc_hd__decap_3
XFILLER_0_5_116 VGND VGND VPWR VPWR sky130_fd_sc_hd__decap_3
XFILLER_0_5_119 VGND VGND VPWR VPWR sky130_fd_sc_hd__decap_3
XFILLER_0_5_122 VGND VGND VPWR VPWR sky130_fd_sc_hd__fill_2
XFILLER_0_5_160 VGND VGND VPWR VPWR sky130_fd_sc_hd__fill_1
XFILLER_0_5_201 VGND VGND VPWR VPWR sky130_fd_sc_hd__decap_3
XFILLER_0_5_204 VGND VGND VPWR VPWR sky130_fd_sc_hd__fill_1
XFILLER_0_5_221 VGND VGND VPWR VPWR sky130_fd_sc_hd__decap_3
XFILLER_0_5_281 VGND VGND VPWR VPWR sky130_fd_sc_hd__decap_3
XFILLER_0_5_284 VGND VGND VPWR VPWR sky130_fd_sc_hd__decap_3
XFILLER_0_5_287 VGND VGND VPWR VPWR sky130_fd_sc_hd__decap_3
XFILLER_0_5_290 VGND VGND VPWR VPWR sky130_fd_sc_hd__decap_3
XFILLER_0_5_293 VGND VGND VPWR VPWR sky130_fd_sc_hd__decap_3
XFILLER_0_5_312 VGND VGND VPWR VPWR sky130_fd_sc_hd__decap_3
XFILLER_0_5_315 VGND VGND VPWR VPWR sky130_fd_sc_hd__fill_2
XFILLER_0_6_3 VGND VGND VPWR VPWR sky130_fd_sc_hd__decap_3
XFILLER_0_6_6 VGND VGND VPWR VPWR sky130_fd_sc_hd__decap_3
XFILLER_0_6_9 VGND VGND VPWR VPWR sky130_fd_sc_hd__decap_3
XFILLER_0_6_12 VGND VGND VPWR VPWR sky130_fd_sc_hd__decap_3
XFILLER_0_6_15 VGND VGND VPWR VPWR sky130_fd_sc_hd__decap_3
XFILLER_0_6_18 VGND VGND VPWR VPWR sky130_fd_sc_hd__decap_3
XFILLER_0_6_21 VGND VGND VPWR VPWR sky130_fd_sc_hd__decap_3
XFILLER_0_6_24 VGND VGND VPWR VPWR sky130_fd_sc_hd__decap_3
XFILLER_0_6_27 VGND VGND VPWR VPWR sky130_fd_sc_hd__fill_1
XFILLER_0_6_29 VGND VGND VPWR VPWR sky130_fd_sc_hd__fill_1
XFILLER_0_6_46 VGND VGND VPWR VPWR sky130_fd_sc_hd__decap_3
XFILLER_0_6_49 VGND VGND VPWR VPWR sky130_fd_sc_hd__decap_3
XFILLER_0_6_85 VGND VGND VPWR VPWR sky130_fd_sc_hd__fill_2
XFILLER_0_6_119 VGND VGND VPWR VPWR sky130_fd_sc_hd__decap_3
XFILLER_0_6_122 VGND VGND VPWR VPWR sky130_fd_sc_hd__fill_2
XFILLER_0_6_141 VGND VGND VPWR VPWR sky130_fd_sc_hd__fill_1
XFILLER_0_6_165 VGND VGND VPWR VPWR sky130_fd_sc_hd__fill_2
XFILLER_0_6_190 VGND VGND VPWR VPWR sky130_fd_sc_hd__decap_3
XFILLER_0_6_193 VGND VGND VPWR VPWR sky130_fd_sc_hd__decap_3
XFILLER_0_6_197 VGND VGND VPWR VPWR sky130_fd_sc_hd__fill_1
XFILLER_0_6_211 VGND VGND VPWR VPWR sky130_fd_sc_hd__fill_1
XFILLER_0_6_235 VGND VGND VPWR VPWR sky130_fd_sc_hd__decap_3
XFILLER_0_6_238 VGND VGND VPWR VPWR sky130_fd_sc_hd__decap_3
XFILLER_0_6_241 VGND VGND VPWR VPWR sky130_fd_sc_hd__decap_3
XFILLER_0_6_251 VGND VGND VPWR VPWR sky130_fd_sc_hd__fill_1
XFILLER_0_6_253 VGND VGND VPWR VPWR sky130_fd_sc_hd__fill_2
XFILLER_0_6_287 VGND VGND VPWR VPWR sky130_fd_sc_hd__fill_2
XFILLER_0_6_291 VGND VGND VPWR VPWR sky130_fd_sc_hd__fill_1
XFILLER_0_6_316 VGND VGND VPWR VPWR sky130_fd_sc_hd__fill_1
XFILLER_0_7_3 VGND VGND VPWR VPWR sky130_fd_sc_hd__decap_3
XFILLER_0_7_6 VGND VGND VPWR VPWR sky130_fd_sc_hd__decap_3
XFILLER_0_7_9 VGND VGND VPWR VPWR sky130_fd_sc_hd__decap_3
XFILLER_0_7_12 VGND VGND VPWR VPWR sky130_fd_sc_hd__decap_3
XFILLER_0_7_15 VGND VGND VPWR VPWR sky130_fd_sc_hd__fill_2
XFILLER_0_7_33 VGND VGND VPWR VPWR sky130_fd_sc_hd__decap_3
XFILLER_0_7_36 VGND VGND VPWR VPWR sky130_fd_sc_hd__decap_3
XFILLER_0_7_39 VGND VGND VPWR VPWR sky130_fd_sc_hd__fill_1
XFILLER_0_7_64 VGND VGND VPWR VPWR sky130_fd_sc_hd__decap_3
XFILLER_0_7_67 VGND VGND VPWR VPWR sky130_fd_sc_hd__fill_1
XFILLER_0_7_84 VGND VGND VPWR VPWR sky130_fd_sc_hd__fill_1
XFILLER_0_7_92 VGND VGND VPWR VPWR sky130_fd_sc_hd__decap_3
XFILLER_0_7_95 VGND VGND VPWR VPWR sky130_fd_sc_hd__fill_1
XFILLER_0_7_129 VGND VGND VPWR VPWR sky130_fd_sc_hd__decap_3
XFILLER_0_7_132 VGND VGND VPWR VPWR sky130_fd_sc_hd__fill_2
XFILLER_0_7_169 VGND VGND VPWR VPWR sky130_fd_sc_hd__decap_3
XFILLER_0_7_172 VGND VGND VPWR VPWR sky130_fd_sc_hd__decap_3
XFILLER_0_7_175 VGND VGND VPWR VPWR sky130_fd_sc_hd__decap_3
XFILLER_0_7_178 VGND VGND VPWR VPWR sky130_fd_sc_hd__decap_3
XFILLER_0_7_181 VGND VGND VPWR VPWR sky130_fd_sc_hd__fill_1
XFILLER_0_7_221 VGND VGND VPWR VPWR sky130_fd_sc_hd__decap_3
XFILLER_0_7_225 VGND VGND VPWR VPWR sky130_fd_sc_hd__decap_3
XFILLER_0_7_228 VGND VGND VPWR VPWR sky130_fd_sc_hd__decap_3
XFILLER_0_7_231 VGND VGND VPWR VPWR sky130_fd_sc_hd__fill_2
XFILLER_0_7_265 VGND VGND VPWR VPWR sky130_fd_sc_hd__decap_3
XFILLER_0_7_268 VGND VGND VPWR VPWR sky130_fd_sc_hd__decap_3
XFILLER_0_7_278 VGND VGND VPWR VPWR sky130_fd_sc_hd__fill_2
XFILLER_0_7_288 VGND VGND VPWR VPWR sky130_fd_sc_hd__decap_3
XFILLER_0_7_291 VGND VGND VPWR VPWR sky130_fd_sc_hd__decap_3
XFILLER_0_8_3 VGND VGND VPWR VPWR sky130_fd_sc_hd__decap_3
XFILLER_0_8_6 VGND VGND VPWR VPWR sky130_fd_sc_hd__decap_3
XFILLER_0_8_9 VGND VGND VPWR VPWR sky130_fd_sc_hd__decap_3
XFILLER_0_8_12 VGND VGND VPWR VPWR sky130_fd_sc_hd__decap_3
XFILLER_0_8_15 VGND VGND VPWR VPWR sky130_fd_sc_hd__decap_3
XFILLER_0_8_18 VGND VGND VPWR VPWR sky130_fd_sc_hd__decap_3
XFILLER_0_8_21 VGND VGND VPWR VPWR sky130_fd_sc_hd__decap_3
XFILLER_0_8_24 VGND VGND VPWR VPWR sky130_fd_sc_hd__decap_3
XFILLER_0_8_27 VGND VGND VPWR VPWR sky130_fd_sc_hd__fill_1
XFILLER_0_8_29 VGND VGND VPWR VPWR sky130_fd_sc_hd__decap_3
XFILLER_0_8_32 VGND VGND VPWR VPWR sky130_fd_sc_hd__decap_3
XFILLER_0_8_35 VGND VGND VPWR VPWR sky130_fd_sc_hd__decap_3
XFILLER_0_8_38 VGND VGND VPWR VPWR sky130_fd_sc_hd__decap_3
XFILLER_0_8_41 VGND VGND VPWR VPWR sky130_fd_sc_hd__decap_3
XFILLER_0_8_44 VGND VGND VPWR VPWR sky130_fd_sc_hd__decap_3
XFILLER_0_8_47 VGND VGND VPWR VPWR sky130_fd_sc_hd__decap_3
XFILLER_0_8_50 VGND VGND VPWR VPWR sky130_fd_sc_hd__decap_3
XFILLER_0_8_53 VGND VGND VPWR VPWR sky130_fd_sc_hd__decap_3
XFILLER_0_8_56 VGND VGND VPWR VPWR sky130_fd_sc_hd__decap_3
XFILLER_0_8_59 VGND VGND VPWR VPWR sky130_fd_sc_hd__decap_3
XFILLER_0_8_62 VGND VGND VPWR VPWR sky130_fd_sc_hd__decap_3
XFILLER_0_8_65 VGND VGND VPWR VPWR sky130_fd_sc_hd__decap_3
XFILLER_0_8_68 VGND VGND VPWR VPWR sky130_fd_sc_hd__decap_3
XFILLER_0_8_71 VGND VGND VPWR VPWR sky130_fd_sc_hd__decap_3
XFILLER_0_8_74 VGND VGND VPWR VPWR sky130_fd_sc_hd__decap_3
XFILLER_0_8_77 VGND VGND VPWR VPWR sky130_fd_sc_hd__fill_1
XFILLER_0_8_92 VGND VGND VPWR VPWR sky130_fd_sc_hd__decap_3
XFILLER_0_8_95 VGND VGND VPWR VPWR sky130_fd_sc_hd__decap_3
XFILLER_0_8_98 VGND VGND VPWR VPWR sky130_fd_sc_hd__decap_3
XFILLER_0_8_101 VGND VGND VPWR VPWR sky130_fd_sc_hd__decap_3
XFILLER_0_8_104 VGND VGND VPWR VPWR sky130_fd_sc_hd__decap_3
XFILLER_0_8_107 VGND VGND VPWR VPWR sky130_fd_sc_hd__decap_3
XFILLER_0_8_110 VGND VGND VPWR VPWR sky130_fd_sc_hd__decap_3
XFILLER_0_8_113 VGND VGND VPWR VPWR sky130_fd_sc_hd__decap_3
XFILLER_0_8_116 VGND VGND VPWR VPWR sky130_fd_sc_hd__decap_3
XFILLER_0_8_119 VGND VGND VPWR VPWR sky130_fd_sc_hd__decap_3
XFILLER_0_8_122 VGND VGND VPWR VPWR sky130_fd_sc_hd__decap_3
XFILLER_0_8_125 VGND VGND VPWR VPWR sky130_fd_sc_hd__decap_3
XFILLER_0_8_128 VGND VGND VPWR VPWR sky130_fd_sc_hd__decap_3
XFILLER_0_8_131 VGND VGND VPWR VPWR sky130_fd_sc_hd__decap_3
XFILLER_0_8_175 VGND VGND VPWR VPWR sky130_fd_sc_hd__decap_3
XFILLER_0_8_178 VGND VGND VPWR VPWR sky130_fd_sc_hd__decap_3
XFILLER_0_8_181 VGND VGND VPWR VPWR sky130_fd_sc_hd__decap_3
XFILLER_0_8_184 VGND VGND VPWR VPWR sky130_fd_sc_hd__decap_3
XFILLER_0_8_187 VGND VGND VPWR VPWR sky130_fd_sc_hd__decap_3
XFILLER_0_8_245 VGND VGND VPWR VPWR sky130_fd_sc_hd__decap_3
XFILLER_0_8_248 VGND VGND VPWR VPWR sky130_fd_sc_hd__decap_3
XFILLER_0_8_251 VGND VGND VPWR VPWR sky130_fd_sc_hd__fill_1
XFILLER_0_8_259 VGND VGND VPWR VPWR sky130_fd_sc_hd__decap_3
XFILLER_0_8_262 VGND VGND VPWR VPWR sky130_fd_sc_hd__decap_3
XFILLER_0_8_265 VGND VGND VPWR VPWR sky130_fd_sc_hd__fill_1
XFILLER_0_8_298 VGND VGND VPWR VPWR sky130_fd_sc_hd__fill_1
XFILLER_0_8_306 VGND VGND VPWR VPWR sky130_fd_sc_hd__fill_2
XFILLER_0_8_309 VGND VGND VPWR VPWR sky130_fd_sc_hd__decap_3
XFILLER_0_8_312 VGND VGND VPWR VPWR sky130_fd_sc_hd__decap_3
XFILLER_0_8_315 VGND VGND VPWR VPWR sky130_fd_sc_hd__fill_2
XFILLER_0_9_3 VGND VGND VPWR VPWR sky130_fd_sc_hd__decap_3
XFILLER_0_9_6 VGND VGND VPWR VPWR sky130_fd_sc_hd__decap_3
XFILLER_0_9_9 VGND VGND VPWR VPWR sky130_fd_sc_hd__decap_3
XFILLER_0_9_12 VGND VGND VPWR VPWR sky130_fd_sc_hd__decap_3
XFILLER_0_9_15 VGND VGND VPWR VPWR sky130_fd_sc_hd__decap_3
XFILLER_0_9_18 VGND VGND VPWR VPWR sky130_fd_sc_hd__decap_3
XFILLER_0_9_21 VGND VGND VPWR VPWR sky130_fd_sc_hd__decap_3
XFILLER_0_9_24 VGND VGND VPWR VPWR sky130_fd_sc_hd__decap_3
XFILLER_0_9_27 VGND VGND VPWR VPWR sky130_fd_sc_hd__decap_3
XFILLER_0_9_30 VGND VGND VPWR VPWR sky130_fd_sc_hd__decap_3
XFILLER_0_9_33 VGND VGND VPWR VPWR sky130_fd_sc_hd__decap_3
XFILLER_0_9_36 VGND VGND VPWR VPWR sky130_fd_sc_hd__decap_3
XFILLER_0_9_39 VGND VGND VPWR VPWR sky130_fd_sc_hd__decap_3
XFILLER_0_9_42 VGND VGND VPWR VPWR sky130_fd_sc_hd__decap_3
XFILLER_0_9_45 VGND VGND VPWR VPWR sky130_fd_sc_hd__decap_3
XFILLER_0_9_48 VGND VGND VPWR VPWR sky130_fd_sc_hd__decap_3
XFILLER_0_9_51 VGND VGND VPWR VPWR sky130_fd_sc_hd__decap_3
XFILLER_0_9_54 VGND VGND VPWR VPWR sky130_fd_sc_hd__fill_2
XFILLER_0_9_57 VGND VGND VPWR VPWR sky130_fd_sc_hd__decap_3
XFILLER_0_9_60 VGND VGND VPWR VPWR sky130_fd_sc_hd__decap_3
XFILLER_0_9_63 VGND VGND VPWR VPWR sky130_fd_sc_hd__decap_3
XFILLER_0_9_66 VGND VGND VPWR VPWR sky130_fd_sc_hd__decap_3
XFILLER_0_9_69 VGND VGND VPWR VPWR sky130_fd_sc_hd__decap_3
XFILLER_0_9_72 VGND VGND VPWR VPWR sky130_fd_sc_hd__decap_3
XFILLER_0_9_75 VGND VGND VPWR VPWR sky130_fd_sc_hd__decap_3
XFILLER_0_9_78 VGND VGND VPWR VPWR sky130_fd_sc_hd__fill_2
XFILLER_0_9_98 VGND VGND VPWR VPWR sky130_fd_sc_hd__decap_3
XFILLER_0_9_101 VGND VGND VPWR VPWR sky130_fd_sc_hd__decap_3
XFILLER_0_9_104 VGND VGND VPWR VPWR sky130_fd_sc_hd__decap_3
XFILLER_0_9_107 VGND VGND VPWR VPWR sky130_fd_sc_hd__decap_3
XFILLER_0_9_110 VGND VGND VPWR VPWR sky130_fd_sc_hd__fill_2
XFILLER_0_9_113 VGND VGND VPWR VPWR sky130_fd_sc_hd__decap_3
XFILLER_0_9_116 VGND VGND VPWR VPWR sky130_fd_sc_hd__decap_3
XFILLER_0_9_119 VGND VGND VPWR VPWR sky130_fd_sc_hd__decap_3
XFILLER_0_9_122 VGND VGND VPWR VPWR sky130_fd_sc_hd__decap_3
XFILLER_0_9_125 VGND VGND VPWR VPWR sky130_fd_sc_hd__decap_3
XFILLER_0_9_128 VGND VGND VPWR VPWR sky130_fd_sc_hd__decap_3
XFILLER_0_9_131 VGND VGND VPWR VPWR sky130_fd_sc_hd__decap_3
XFILLER_0_9_158 VGND VGND VPWR VPWR sky130_fd_sc_hd__decap_3
XFILLER_0_9_161 VGND VGND VPWR VPWR sky130_fd_sc_hd__decap_3
XFILLER_0_9_164 VGND VGND VPWR VPWR sky130_fd_sc_hd__decap_3
XFILLER_0_9_167 VGND VGND VPWR VPWR sky130_fd_sc_hd__fill_1
XFILLER_0_9_169 VGND VGND VPWR VPWR sky130_fd_sc_hd__decap_3
XFILLER_0_9_172 VGND VGND VPWR VPWR sky130_fd_sc_hd__fill_1
XFILLER_0_9_221 VGND VGND VPWR VPWR sky130_fd_sc_hd__decap_3
XFILLER_0_9_241 VGND VGND VPWR VPWR sky130_fd_sc_hd__fill_2
XFILLER_0_9_261 VGND VGND VPWR VPWR sky130_fd_sc_hd__decap_3
XFILLER_0_9_313 VGND VGND VPWR VPWR sky130_fd_sc_hd__fill_2
XFILLER_0_10_3 VGND VGND VPWR VPWR sky130_fd_sc_hd__decap_3
XFILLER_0_10_6 VGND VGND VPWR VPWR sky130_fd_sc_hd__decap_3
XFILLER_0_10_9 VGND VGND VPWR VPWR sky130_fd_sc_hd__decap_3
XFILLER_0_10_12 VGND VGND VPWR VPWR sky130_fd_sc_hd__decap_3
XFILLER_0_10_15 VGND VGND VPWR VPWR sky130_fd_sc_hd__decap_3
XFILLER_0_10_18 VGND VGND VPWR VPWR sky130_fd_sc_hd__decap_3
XFILLER_0_10_21 VGND VGND VPWR VPWR sky130_fd_sc_hd__decap_3
XFILLER_0_10_24 VGND VGND VPWR VPWR sky130_fd_sc_hd__decap_3
XFILLER_0_10_27 VGND VGND VPWR VPWR sky130_fd_sc_hd__fill_1
XFILLER_0_10_29 VGND VGND VPWR VPWR sky130_fd_sc_hd__decap_3
XFILLER_0_10_32 VGND VGND VPWR VPWR sky130_fd_sc_hd__decap_3
XFILLER_0_10_35 VGND VGND VPWR VPWR sky130_fd_sc_hd__decap_3
XFILLER_0_10_38 VGND VGND VPWR VPWR sky130_fd_sc_hd__decap_3
XFILLER_0_10_41 VGND VGND VPWR VPWR sky130_fd_sc_hd__decap_3
XFILLER_0_10_44 VGND VGND VPWR VPWR sky130_fd_sc_hd__decap_3
XFILLER_0_10_47 VGND VGND VPWR VPWR sky130_fd_sc_hd__decap_3
XFILLER_0_10_50 VGND VGND VPWR VPWR sky130_fd_sc_hd__decap_3
XFILLER_0_10_53 VGND VGND VPWR VPWR sky130_fd_sc_hd__decap_3
XFILLER_0_10_56 VGND VGND VPWR VPWR sky130_fd_sc_hd__decap_3
XFILLER_0_10_59 VGND VGND VPWR VPWR sky130_fd_sc_hd__decap_3
XFILLER_0_10_62 VGND VGND VPWR VPWR sky130_fd_sc_hd__decap_3
XFILLER_0_10_65 VGND VGND VPWR VPWR sky130_fd_sc_hd__decap_3
XFILLER_0_10_68 VGND VGND VPWR VPWR sky130_fd_sc_hd__decap_3
XFILLER_0_10_71 VGND VGND VPWR VPWR sky130_fd_sc_hd__decap_3
XFILLER_0_10_74 VGND VGND VPWR VPWR sky130_fd_sc_hd__decap_3
XFILLER_0_10_77 VGND VGND VPWR VPWR sky130_fd_sc_hd__decap_3
XFILLER_0_10_80 VGND VGND VPWR VPWR sky130_fd_sc_hd__decap_3
XFILLER_0_10_83 VGND VGND VPWR VPWR sky130_fd_sc_hd__fill_1
XFILLER_0_10_85 VGND VGND VPWR VPWR sky130_fd_sc_hd__decap_3
XFILLER_0_10_88 VGND VGND VPWR VPWR sky130_fd_sc_hd__decap_3
XFILLER_0_10_91 VGND VGND VPWR VPWR sky130_fd_sc_hd__decap_3
XFILLER_0_10_94 VGND VGND VPWR VPWR sky130_fd_sc_hd__decap_3
XFILLER_0_10_97 VGND VGND VPWR VPWR sky130_fd_sc_hd__decap_3
XFILLER_0_10_100 VGND VGND VPWR VPWR sky130_fd_sc_hd__decap_3
XFILLER_0_10_103 VGND VGND VPWR VPWR sky130_fd_sc_hd__decap_3
XFILLER_0_10_106 VGND VGND VPWR VPWR sky130_fd_sc_hd__decap_3
XFILLER_0_10_109 VGND VGND VPWR VPWR sky130_fd_sc_hd__decap_3
XFILLER_0_10_112 VGND VGND VPWR VPWR sky130_fd_sc_hd__decap_3
XFILLER_0_10_115 VGND VGND VPWR VPWR sky130_fd_sc_hd__decap_3
XFILLER_0_10_118 VGND VGND VPWR VPWR sky130_fd_sc_hd__decap_3
XFILLER_0_10_121 VGND VGND VPWR VPWR sky130_fd_sc_hd__decap_3
XFILLER_0_10_124 VGND VGND VPWR VPWR sky130_fd_sc_hd__decap_3
XFILLER_0_10_127 VGND VGND VPWR VPWR sky130_fd_sc_hd__decap_3
XFILLER_0_10_130 VGND VGND VPWR VPWR sky130_fd_sc_hd__decap_3
XFILLER_0_10_133 VGND VGND VPWR VPWR sky130_fd_sc_hd__decap_3
XFILLER_0_10_136 VGND VGND VPWR VPWR sky130_fd_sc_hd__decap_3
XFILLER_0_10_139 VGND VGND VPWR VPWR sky130_fd_sc_hd__fill_1
XFILLER_0_10_141 VGND VGND VPWR VPWR sky130_fd_sc_hd__decap_3
XFILLER_0_10_144 VGND VGND VPWR VPWR sky130_fd_sc_hd__decap_3
XFILLER_0_10_147 VGND VGND VPWR VPWR sky130_fd_sc_hd__decap_3
XFILLER_0_10_150 VGND VGND VPWR VPWR sky130_fd_sc_hd__decap_3
XFILLER_0_10_153 VGND VGND VPWR VPWR sky130_fd_sc_hd__decap_3
XFILLER_0_10_156 VGND VGND VPWR VPWR sky130_fd_sc_hd__decap_3
XFILLER_0_10_159 VGND VGND VPWR VPWR sky130_fd_sc_hd__decap_3
XFILLER_0_10_162 VGND VGND VPWR VPWR sky130_fd_sc_hd__decap_3
XFILLER_0_10_165 VGND VGND VPWR VPWR sky130_fd_sc_hd__decap_3
XFILLER_0_10_168 VGND VGND VPWR VPWR sky130_fd_sc_hd__decap_3
XFILLER_0_10_171 VGND VGND VPWR VPWR sky130_fd_sc_hd__decap_3
XFILLER_0_10_174 VGND VGND VPWR VPWR sky130_fd_sc_hd__decap_3
XFILLER_0_10_177 VGND VGND VPWR VPWR sky130_fd_sc_hd__decap_3
XFILLER_0_10_180 VGND VGND VPWR VPWR sky130_fd_sc_hd__decap_3
XFILLER_0_10_183 VGND VGND VPWR VPWR sky130_fd_sc_hd__decap_3
XFILLER_0_10_186 VGND VGND VPWR VPWR sky130_fd_sc_hd__decap_3
XFILLER_0_10_189 VGND VGND VPWR VPWR sky130_fd_sc_hd__decap_3
XFILLER_0_10_192 VGND VGND VPWR VPWR sky130_fd_sc_hd__decap_3
XFILLER_0_10_195 VGND VGND VPWR VPWR sky130_fd_sc_hd__fill_1
XFILLER_0_10_197 VGND VGND VPWR VPWR sky130_fd_sc_hd__fill_1
XFILLER_0_10_205 VGND VGND VPWR VPWR sky130_fd_sc_hd__decap_3
XFILLER_0_10_208 VGND VGND VPWR VPWR sky130_fd_sc_hd__fill_2
XFILLER_0_10_246 VGND VGND VPWR VPWR sky130_fd_sc_hd__decap_3
XFILLER_0_10_249 VGND VGND VPWR VPWR sky130_fd_sc_hd__decap_3
XFILLER_0_10_253 VGND VGND VPWR VPWR sky130_fd_sc_hd__fill_1
XFILLER_0_10_260 VGND VGND VPWR VPWR sky130_fd_sc_hd__decap_3
XFILLER_0_10_263 VGND VGND VPWR VPWR sky130_fd_sc_hd__decap_3
XFILLER_0_10_266 VGND VGND VPWR VPWR sky130_fd_sc_hd__decap_3
XFILLER_0_10_269 VGND VGND VPWR VPWR sky130_fd_sc_hd__decap_3
XFILLER_0_10_272 VGND VGND VPWR VPWR sky130_fd_sc_hd__decap_3
XFILLER_0_10_275 VGND VGND VPWR VPWR sky130_fd_sc_hd__fill_1
XFILLER_0_10_283 VGND VGND VPWR VPWR sky130_fd_sc_hd__decap_3
XFILLER_0_10_286 VGND VGND VPWR VPWR sky130_fd_sc_hd__decap_3
XFILLER_0_10_289 VGND VGND VPWR VPWR sky130_fd_sc_hd__decap_3
XFILLER_0_10_292 VGND VGND VPWR VPWR sky130_fd_sc_hd__decap_3
XFILLER_0_10_295 VGND VGND VPWR VPWR sky130_fd_sc_hd__fill_2
XFILLER_0_10_299 VGND VGND VPWR VPWR sky130_fd_sc_hd__decap_3
XFILLER_0_10_302 VGND VGND VPWR VPWR sky130_fd_sc_hd__decap_3
XFILLER_0_10_305 VGND VGND VPWR VPWR sky130_fd_sc_hd__decap_3
XFILLER_0_10_309 VGND VGND VPWR VPWR sky130_fd_sc_hd__decap_3
XFILLER_0_10_312 VGND VGND VPWR VPWR sky130_fd_sc_hd__decap_3
XFILLER_0_10_315 VGND VGND VPWR VPWR sky130_fd_sc_hd__fill_2
XFILLER_0_11_3 VGND VGND VPWR VPWR sky130_fd_sc_hd__decap_3
XFILLER_0_11_6 VGND VGND VPWR VPWR sky130_fd_sc_hd__decap_3
XFILLER_0_11_9 VGND VGND VPWR VPWR sky130_fd_sc_hd__decap_3
XFILLER_0_11_12 VGND VGND VPWR VPWR sky130_fd_sc_hd__decap_3
XFILLER_0_11_15 VGND VGND VPWR VPWR sky130_fd_sc_hd__decap_3
XFILLER_0_11_18 VGND VGND VPWR VPWR sky130_fd_sc_hd__fill_1
XFILLER_0_11_27 VGND VGND VPWR VPWR sky130_fd_sc_hd__decap_3
XFILLER_0_11_30 VGND VGND VPWR VPWR sky130_fd_sc_hd__decap_3
XFILLER_0_11_33 VGND VGND VPWR VPWR sky130_fd_sc_hd__decap_3
XFILLER_0_11_36 VGND VGND VPWR VPWR sky130_fd_sc_hd__decap_3
XFILLER_0_11_39 VGND VGND VPWR VPWR sky130_fd_sc_hd__decap_3
XFILLER_0_11_42 VGND VGND VPWR VPWR sky130_fd_sc_hd__decap_3
XFILLER_0_11_45 VGND VGND VPWR VPWR sky130_fd_sc_hd__decap_3
XFILLER_0_11_48 VGND VGND VPWR VPWR sky130_fd_sc_hd__decap_3
XFILLER_0_11_51 VGND VGND VPWR VPWR sky130_fd_sc_hd__decap_3
XFILLER_0_11_54 VGND VGND VPWR VPWR sky130_fd_sc_hd__fill_2
XFILLER_0_11_57 VGND VGND VPWR VPWR sky130_fd_sc_hd__decap_3
XFILLER_0_11_60 VGND VGND VPWR VPWR sky130_fd_sc_hd__decap_3
XFILLER_0_11_63 VGND VGND VPWR VPWR sky130_fd_sc_hd__decap_3
XFILLER_0_11_66 VGND VGND VPWR VPWR sky130_fd_sc_hd__decap_3
XFILLER_0_11_69 VGND VGND VPWR VPWR sky130_fd_sc_hd__decap_3
XFILLER_0_11_72 VGND VGND VPWR VPWR sky130_fd_sc_hd__decap_3
XFILLER_0_11_75 VGND VGND VPWR VPWR sky130_fd_sc_hd__decap_3
XFILLER_0_11_78 VGND VGND VPWR VPWR sky130_fd_sc_hd__decap_3
XFILLER_0_11_81 VGND VGND VPWR VPWR sky130_fd_sc_hd__decap_3
XFILLER_0_11_84 VGND VGND VPWR VPWR sky130_fd_sc_hd__decap_3
XFILLER_0_11_87 VGND VGND VPWR VPWR sky130_fd_sc_hd__decap_3
XFILLER_0_11_90 VGND VGND VPWR VPWR sky130_fd_sc_hd__decap_3
XFILLER_0_11_93 VGND VGND VPWR VPWR sky130_fd_sc_hd__decap_3
XFILLER_0_11_96 VGND VGND VPWR VPWR sky130_fd_sc_hd__decap_3
XFILLER_0_11_99 VGND VGND VPWR VPWR sky130_fd_sc_hd__decap_3
XFILLER_0_11_102 VGND VGND VPWR VPWR sky130_fd_sc_hd__decap_3
XFILLER_0_11_105 VGND VGND VPWR VPWR sky130_fd_sc_hd__decap_3
XFILLER_0_11_108 VGND VGND VPWR VPWR sky130_fd_sc_hd__decap_3
XFILLER_0_11_111 VGND VGND VPWR VPWR sky130_fd_sc_hd__fill_1
XFILLER_0_11_113 VGND VGND VPWR VPWR sky130_fd_sc_hd__decap_3
XFILLER_0_11_116 VGND VGND VPWR VPWR sky130_fd_sc_hd__decap_3
XFILLER_0_11_119 VGND VGND VPWR VPWR sky130_fd_sc_hd__decap_3
XFILLER_0_11_122 VGND VGND VPWR VPWR sky130_fd_sc_hd__decap_3
XFILLER_0_11_125 VGND VGND VPWR VPWR sky130_fd_sc_hd__decap_3
XFILLER_0_11_134 VGND VGND VPWR VPWR sky130_fd_sc_hd__fill_2
XFILLER_0_11_138 VGND VGND VPWR VPWR sky130_fd_sc_hd__decap_3
XFILLER_0_11_141 VGND VGND VPWR VPWR sky130_fd_sc_hd__decap_3
XFILLER_0_11_144 VGND VGND VPWR VPWR sky130_fd_sc_hd__decap_3
XFILLER_0_11_147 VGND VGND VPWR VPWR sky130_fd_sc_hd__decap_3
XFILLER_0_11_150 VGND VGND VPWR VPWR sky130_fd_sc_hd__decap_3
XFILLER_0_11_153 VGND VGND VPWR VPWR sky130_fd_sc_hd__decap_3
XFILLER_0_11_156 VGND VGND VPWR VPWR sky130_fd_sc_hd__decap_3
XFILLER_0_11_159 VGND VGND VPWR VPWR sky130_fd_sc_hd__decap_3
XFILLER_0_11_162 VGND VGND VPWR VPWR sky130_fd_sc_hd__decap_3
XFILLER_0_11_165 VGND VGND VPWR VPWR sky130_fd_sc_hd__decap_3
XFILLER_0_11_169 VGND VGND VPWR VPWR sky130_fd_sc_hd__decap_3
XFILLER_0_11_172 VGND VGND VPWR VPWR sky130_fd_sc_hd__decap_3
XFILLER_0_11_175 VGND VGND VPWR VPWR sky130_fd_sc_hd__decap_3
XFILLER_0_11_178 VGND VGND VPWR VPWR sky130_fd_sc_hd__decap_3
XFILLER_0_11_181 VGND VGND VPWR VPWR sky130_fd_sc_hd__decap_3
XFILLER_0_11_184 VGND VGND VPWR VPWR sky130_fd_sc_hd__decap_3
XFILLER_0_11_187 VGND VGND VPWR VPWR sky130_fd_sc_hd__decap_3
XFILLER_0_11_190 VGND VGND VPWR VPWR sky130_fd_sc_hd__decap_3
XFILLER_0_11_193 VGND VGND VPWR VPWR sky130_fd_sc_hd__decap_3
XFILLER_0_11_196 VGND VGND VPWR VPWR sky130_fd_sc_hd__decap_3
XFILLER_0_11_199 VGND VGND VPWR VPWR sky130_fd_sc_hd__decap_3
XFILLER_0_11_202 VGND VGND VPWR VPWR sky130_fd_sc_hd__decap_3
XFILLER_0_11_205 VGND VGND VPWR VPWR sky130_fd_sc_hd__decap_3
XFILLER_0_11_208 VGND VGND VPWR VPWR sky130_fd_sc_hd__decap_3
XFILLER_0_11_211 VGND VGND VPWR VPWR sky130_fd_sc_hd__decap_3
XFILLER_0_11_214 VGND VGND VPWR VPWR sky130_fd_sc_hd__decap_3
XFILLER_0_11_217 VGND VGND VPWR VPWR sky130_fd_sc_hd__decap_3
XFILLER_0_11_220 VGND VGND VPWR VPWR sky130_fd_sc_hd__decap_3
XFILLER_0_11_223 VGND VGND VPWR VPWR sky130_fd_sc_hd__fill_1
XFILLER_0_11_225 VGND VGND VPWR VPWR sky130_fd_sc_hd__decap_3
XFILLER_0_11_228 VGND VGND VPWR VPWR sky130_fd_sc_hd__decap_3
XFILLER_0_11_231 VGND VGND VPWR VPWR sky130_fd_sc_hd__decap_3
XFILLER_0_11_234 VGND VGND VPWR VPWR sky130_fd_sc_hd__decap_3
XFILLER_0_11_237 VGND VGND VPWR VPWR sky130_fd_sc_hd__decap_3
XFILLER_0_11_240 VGND VGND VPWR VPWR sky130_fd_sc_hd__decap_3
XFILLER_0_11_243 VGND VGND VPWR VPWR sky130_fd_sc_hd__decap_3
XFILLER_0_11_246 VGND VGND VPWR VPWR sky130_fd_sc_hd__decap_3
XFILLER_0_11_249 VGND VGND VPWR VPWR sky130_fd_sc_hd__decap_3
XFILLER_0_11_252 VGND VGND VPWR VPWR sky130_fd_sc_hd__decap_3
XFILLER_0_11_255 VGND VGND VPWR VPWR sky130_fd_sc_hd__decap_3
XFILLER_0_11_258 VGND VGND VPWR VPWR sky130_fd_sc_hd__decap_3
XFILLER_0_11_261 VGND VGND VPWR VPWR sky130_fd_sc_hd__decap_3
XFILLER_0_11_264 VGND VGND VPWR VPWR sky130_fd_sc_hd__decap_3
XFILLER_0_11_267 VGND VGND VPWR VPWR sky130_fd_sc_hd__decap_3
XFILLER_0_11_270 VGND VGND VPWR VPWR sky130_fd_sc_hd__decap_3
XFILLER_0_11_273 VGND VGND VPWR VPWR sky130_fd_sc_hd__decap_3
XFILLER_0_11_276 VGND VGND VPWR VPWR sky130_fd_sc_hd__decap_3
XFILLER_0_11_279 VGND VGND VPWR VPWR sky130_fd_sc_hd__fill_1
XFILLER_0_11_281 VGND VGND VPWR VPWR sky130_fd_sc_hd__decap_3
XFILLER_0_11_284 VGND VGND VPWR VPWR sky130_fd_sc_hd__decap_3
XFILLER_0_11_287 VGND VGND VPWR VPWR sky130_fd_sc_hd__decap_3
XFILLER_0_11_290 VGND VGND VPWR VPWR sky130_fd_sc_hd__decap_3
XFILLER_0_11_293 VGND VGND VPWR VPWR sky130_fd_sc_hd__decap_3
XFILLER_0_11_296 VGND VGND VPWR VPWR sky130_fd_sc_hd__decap_3
XFILLER_0_11_299 VGND VGND VPWR VPWR sky130_fd_sc_hd__decap_3
XFILLER_0_11_302 VGND VGND VPWR VPWR sky130_fd_sc_hd__decap_3
XFILLER_0_11_305 VGND VGND VPWR VPWR sky130_fd_sc_hd__decap_3
XFILLER_0_11_308 VGND VGND VPWR VPWR sky130_fd_sc_hd__decap_3
XFILLER_0_11_311 VGND VGND VPWR VPWR sky130_fd_sc_hd__decap_3
XFILLER_0_11_314 VGND VGND VPWR VPWR sky130_fd_sc_hd__decap_3
XFILLER_0_12_3 VGND VGND VPWR VPWR sky130_fd_sc_hd__decap_3
XFILLER_0_12_6 VGND VGND VPWR VPWR sky130_fd_sc_hd__decap_3
XFILLER_0_12_9 VGND VGND VPWR VPWR sky130_fd_sc_hd__decap_3
XFILLER_0_12_12 VGND VGND VPWR VPWR sky130_fd_sc_hd__decap_3
XFILLER_0_12_15 VGND VGND VPWR VPWR sky130_fd_sc_hd__decap_3
XFILLER_0_12_18 VGND VGND VPWR VPWR sky130_fd_sc_hd__decap_3
XFILLER_0_12_21 VGND VGND VPWR VPWR sky130_fd_sc_hd__decap_3
XFILLER_0_12_24 VGND VGND VPWR VPWR sky130_fd_sc_hd__decap_3
XFILLER_0_12_27 VGND VGND VPWR VPWR sky130_fd_sc_hd__fill_1
XFILLER_0_12_29 VGND VGND VPWR VPWR sky130_fd_sc_hd__decap_3
XFILLER_0_12_32 VGND VGND VPWR VPWR sky130_fd_sc_hd__decap_3
XFILLER_0_12_35 VGND VGND VPWR VPWR sky130_fd_sc_hd__decap_3
XFILLER_0_12_38 VGND VGND VPWR VPWR sky130_fd_sc_hd__decap_3
XFILLER_0_12_41 VGND VGND VPWR VPWR sky130_fd_sc_hd__decap_3
XFILLER_0_12_44 VGND VGND VPWR VPWR sky130_fd_sc_hd__decap_3
XFILLER_0_12_47 VGND VGND VPWR VPWR sky130_fd_sc_hd__decap_3
XFILLER_0_12_50 VGND VGND VPWR VPWR sky130_fd_sc_hd__decap_3
XFILLER_0_12_53 VGND VGND VPWR VPWR sky130_fd_sc_hd__decap_3
XFILLER_0_12_56 VGND VGND VPWR VPWR sky130_fd_sc_hd__decap_3
XFILLER_0_12_59 VGND VGND VPWR VPWR sky130_fd_sc_hd__decap_3
XFILLER_0_12_62 VGND VGND VPWR VPWR sky130_fd_sc_hd__decap_3
XFILLER_0_12_65 VGND VGND VPWR VPWR sky130_fd_sc_hd__decap_3
XFILLER_0_12_68 VGND VGND VPWR VPWR sky130_fd_sc_hd__decap_3
XFILLER_0_12_71 VGND VGND VPWR VPWR sky130_fd_sc_hd__decap_3
XFILLER_0_12_74 VGND VGND VPWR VPWR sky130_fd_sc_hd__decap_3
XFILLER_0_12_77 VGND VGND VPWR VPWR sky130_fd_sc_hd__decap_3
XFILLER_0_12_80 VGND VGND VPWR VPWR sky130_fd_sc_hd__decap_3
XFILLER_0_12_83 VGND VGND VPWR VPWR sky130_fd_sc_hd__fill_1
XFILLER_0_12_85 VGND VGND VPWR VPWR sky130_fd_sc_hd__decap_3
XFILLER_0_12_88 VGND VGND VPWR VPWR sky130_fd_sc_hd__decap_3
XFILLER_0_12_91 VGND VGND VPWR VPWR sky130_fd_sc_hd__decap_3
XFILLER_0_12_94 VGND VGND VPWR VPWR sky130_fd_sc_hd__decap_3
XFILLER_0_12_97 VGND VGND VPWR VPWR sky130_fd_sc_hd__decap_3
XFILLER_0_12_100 VGND VGND VPWR VPWR sky130_fd_sc_hd__decap_3
XFILLER_0_12_103 VGND VGND VPWR VPWR sky130_fd_sc_hd__decap_3
XFILLER_0_12_106 VGND VGND VPWR VPWR sky130_fd_sc_hd__decap_3
XFILLER_0_12_109 VGND VGND VPWR VPWR sky130_fd_sc_hd__decap_3
XFILLER_0_12_112 VGND VGND VPWR VPWR sky130_fd_sc_hd__decap_3
XFILLER_0_12_115 VGND VGND VPWR VPWR sky130_fd_sc_hd__decap_3
XFILLER_0_12_118 VGND VGND VPWR VPWR sky130_fd_sc_hd__decap_3
XFILLER_0_12_121 VGND VGND VPWR VPWR sky130_fd_sc_hd__decap_3
XFILLER_0_12_124 VGND VGND VPWR VPWR sky130_fd_sc_hd__decap_3
XFILLER_0_12_127 VGND VGND VPWR VPWR sky130_fd_sc_hd__decap_3
XFILLER_0_12_130 VGND VGND VPWR VPWR sky130_fd_sc_hd__decap_3
XFILLER_0_12_133 VGND VGND VPWR VPWR sky130_fd_sc_hd__decap_3
XFILLER_0_12_136 VGND VGND VPWR VPWR sky130_fd_sc_hd__decap_3
XFILLER_0_12_139 VGND VGND VPWR VPWR sky130_fd_sc_hd__fill_1
XFILLER_0_12_141 VGND VGND VPWR VPWR sky130_fd_sc_hd__decap_3
XFILLER_0_12_144 VGND VGND VPWR VPWR sky130_fd_sc_hd__decap_3
XFILLER_0_12_147 VGND VGND VPWR VPWR sky130_fd_sc_hd__decap_3
XFILLER_0_12_150 VGND VGND VPWR VPWR sky130_fd_sc_hd__decap_3
XFILLER_0_12_153 VGND VGND VPWR VPWR sky130_fd_sc_hd__decap_3
XFILLER_0_12_156 VGND VGND VPWR VPWR sky130_fd_sc_hd__decap_3
XFILLER_0_12_159 VGND VGND VPWR VPWR sky130_fd_sc_hd__decap_3
XFILLER_0_12_162 VGND VGND VPWR VPWR sky130_fd_sc_hd__decap_3
XFILLER_0_12_165 VGND VGND VPWR VPWR sky130_fd_sc_hd__decap_3
XFILLER_0_12_168 VGND VGND VPWR VPWR sky130_fd_sc_hd__decap_3
XFILLER_0_12_171 VGND VGND VPWR VPWR sky130_fd_sc_hd__decap_3
XFILLER_0_12_174 VGND VGND VPWR VPWR sky130_fd_sc_hd__decap_3
XFILLER_0_12_177 VGND VGND VPWR VPWR sky130_fd_sc_hd__decap_3
XFILLER_0_12_180 VGND VGND VPWR VPWR sky130_fd_sc_hd__decap_3
XFILLER_0_12_183 VGND VGND VPWR VPWR sky130_fd_sc_hd__decap_3
XFILLER_0_12_186 VGND VGND VPWR VPWR sky130_fd_sc_hd__decap_3
XFILLER_0_12_189 VGND VGND VPWR VPWR sky130_fd_sc_hd__decap_3
XFILLER_0_12_192 VGND VGND VPWR VPWR sky130_fd_sc_hd__decap_3
XFILLER_0_12_195 VGND VGND VPWR VPWR sky130_fd_sc_hd__fill_1
XFILLER_0_12_197 VGND VGND VPWR VPWR sky130_fd_sc_hd__decap_3
XFILLER_0_12_200 VGND VGND VPWR VPWR sky130_fd_sc_hd__decap_3
XFILLER_0_12_203 VGND VGND VPWR VPWR sky130_fd_sc_hd__decap_3
XFILLER_0_12_206 VGND VGND VPWR VPWR sky130_fd_sc_hd__decap_3
XFILLER_0_12_229 VGND VGND VPWR VPWR sky130_fd_sc_hd__fill_1
XFILLER_0_12_246 VGND VGND VPWR VPWR sky130_fd_sc_hd__decap_3
XFILLER_0_12_249 VGND VGND VPWR VPWR sky130_fd_sc_hd__decap_3
XFILLER_0_12_253 VGND VGND VPWR VPWR sky130_fd_sc_hd__decap_3
XFILLER_0_12_256 VGND VGND VPWR VPWR sky130_fd_sc_hd__decap_3
XFILLER_0_12_259 VGND VGND VPWR VPWR sky130_fd_sc_hd__decap_3
XFILLER_0_12_262 VGND VGND VPWR VPWR sky130_fd_sc_hd__decap_3
XFILLER_0_12_265 VGND VGND VPWR VPWR sky130_fd_sc_hd__decap_3
XFILLER_0_12_268 VGND VGND VPWR VPWR sky130_fd_sc_hd__fill_2
XFILLER_0_12_286 VGND VGND VPWR VPWR sky130_fd_sc_hd__decap_3
XFILLER_0_12_289 VGND VGND VPWR VPWR sky130_fd_sc_hd__decap_3
XFILLER_0_12_292 VGND VGND VPWR VPWR sky130_fd_sc_hd__decap_3
XFILLER_0_12_295 VGND VGND VPWR VPWR sky130_fd_sc_hd__decap_3
XFILLER_0_12_298 VGND VGND VPWR VPWR sky130_fd_sc_hd__decap_3
XFILLER_0_12_301 VGND VGND VPWR VPWR sky130_fd_sc_hd__decap_3
XFILLER_0_12_304 VGND VGND VPWR VPWR sky130_fd_sc_hd__decap_3
XFILLER_0_12_307 VGND VGND VPWR VPWR sky130_fd_sc_hd__fill_1
XFILLER_0_12_309 VGND VGND VPWR VPWR sky130_fd_sc_hd__decap_3
XFILLER_0_12_312 VGND VGND VPWR VPWR sky130_fd_sc_hd__decap_3
XFILLER_0_12_315 VGND VGND VPWR VPWR sky130_fd_sc_hd__fill_2
XFILLER_0_13_9 VGND VGND VPWR VPWR sky130_fd_sc_hd__decap_3
XFILLER_0_13_12 VGND VGND VPWR VPWR sky130_fd_sc_hd__decap_3
XFILLER_0_13_15 VGND VGND VPWR VPWR sky130_fd_sc_hd__decap_3
XFILLER_0_13_18 VGND VGND VPWR VPWR sky130_fd_sc_hd__decap_3
XFILLER_0_13_21 VGND VGND VPWR VPWR sky130_fd_sc_hd__decap_3
XFILLER_0_13_24 VGND VGND VPWR VPWR sky130_fd_sc_hd__decap_3
XFILLER_0_13_27 VGND VGND VPWR VPWR sky130_fd_sc_hd__decap_3
XFILLER_0_13_30 VGND VGND VPWR VPWR sky130_fd_sc_hd__decap_3
XFILLER_0_13_33 VGND VGND VPWR VPWR sky130_fd_sc_hd__decap_3
XFILLER_0_13_36 VGND VGND VPWR VPWR sky130_fd_sc_hd__decap_3
XFILLER_0_13_39 VGND VGND VPWR VPWR sky130_fd_sc_hd__decap_3
XFILLER_0_13_42 VGND VGND VPWR VPWR sky130_fd_sc_hd__decap_3
XFILLER_0_13_45 VGND VGND VPWR VPWR sky130_fd_sc_hd__decap_3
XFILLER_0_13_48 VGND VGND VPWR VPWR sky130_fd_sc_hd__decap_3
XFILLER_0_13_51 VGND VGND VPWR VPWR sky130_fd_sc_hd__decap_3
XFILLER_0_13_54 VGND VGND VPWR VPWR sky130_fd_sc_hd__fill_2
XFILLER_0_13_57 VGND VGND VPWR VPWR sky130_fd_sc_hd__decap_3
XFILLER_0_13_60 VGND VGND VPWR VPWR sky130_fd_sc_hd__fill_2
XFILLER_0_13_64 VGND VGND VPWR VPWR sky130_fd_sc_hd__decap_3
XFILLER_0_13_67 VGND VGND VPWR VPWR sky130_fd_sc_hd__fill_2
XFILLER_0_13_92 VGND VGND VPWR VPWR sky130_fd_sc_hd__fill_2
XFILLER_0_13_96 VGND VGND VPWR VPWR sky130_fd_sc_hd__decap_3
XFILLER_0_13_99 VGND VGND VPWR VPWR sky130_fd_sc_hd__decap_3
XFILLER_0_13_102 VGND VGND VPWR VPWR sky130_fd_sc_hd__decap_3
XFILLER_0_13_105 VGND VGND VPWR VPWR sky130_fd_sc_hd__decap_3
XFILLER_0_13_108 VGND VGND VPWR VPWR sky130_fd_sc_hd__decap_3
XFILLER_0_13_111 VGND VGND VPWR VPWR sky130_fd_sc_hd__fill_1
XFILLER_0_13_113 VGND VGND VPWR VPWR sky130_fd_sc_hd__decap_3
XFILLER_0_13_116 VGND VGND VPWR VPWR sky130_fd_sc_hd__decap_3
XFILLER_0_13_119 VGND VGND VPWR VPWR sky130_fd_sc_hd__decap_3
XFILLER_0_13_122 VGND VGND VPWR VPWR sky130_fd_sc_hd__decap_3
XFILLER_0_13_125 VGND VGND VPWR VPWR sky130_fd_sc_hd__decap_3
XFILLER_0_13_128 VGND VGND VPWR VPWR sky130_fd_sc_hd__decap_3
XFILLER_0_13_163 VGND VGND VPWR VPWR sky130_fd_sc_hd__decap_3
XFILLER_0_13_166 VGND VGND VPWR VPWR sky130_fd_sc_hd__fill_2
XFILLER_0_13_185 VGND VGND VPWR VPWR sky130_fd_sc_hd__decap_3
XFILLER_0_13_225 VGND VGND VPWR VPWR sky130_fd_sc_hd__decap_3
XFILLER_0_13_228 VGND VGND VPWR VPWR sky130_fd_sc_hd__decap_3
XFILLER_0_13_231 VGND VGND VPWR VPWR sky130_fd_sc_hd__fill_2
XFILLER_0_13_253 VGND VGND VPWR VPWR sky130_fd_sc_hd__fill_1
XFILLER_0_13_270 VGND VGND VPWR VPWR sky130_fd_sc_hd__decap_3
XFILLER_0_13_273 VGND VGND VPWR VPWR sky130_fd_sc_hd__decap_3
XFILLER_0_13_276 VGND VGND VPWR VPWR sky130_fd_sc_hd__decap_3
XFILLER_0_13_279 VGND VGND VPWR VPWR sky130_fd_sc_hd__fill_1
XFILLER_0_13_281 VGND VGND VPWR VPWR sky130_fd_sc_hd__decap_3
XFILLER_0_13_284 VGND VGND VPWR VPWR sky130_fd_sc_hd__decap_3
XFILLER_0_13_287 VGND VGND VPWR VPWR sky130_fd_sc_hd__decap_3
XFILLER_0_13_290 VGND VGND VPWR VPWR sky130_fd_sc_hd__decap_3
XFILLER_0_13_293 VGND VGND VPWR VPWR sky130_fd_sc_hd__decap_3
XFILLER_0_13_296 VGND VGND VPWR VPWR sky130_fd_sc_hd__decap_3
XFILLER_0_13_299 VGND VGND VPWR VPWR sky130_fd_sc_hd__decap_3
XFILLER_0_13_302 VGND VGND VPWR VPWR sky130_fd_sc_hd__decap_3
XFILLER_0_13_305 VGND VGND VPWR VPWR sky130_fd_sc_hd__decap_3
XFILLER_0_13_308 VGND VGND VPWR VPWR sky130_fd_sc_hd__decap_3
XFILLER_0_13_311 VGND VGND VPWR VPWR sky130_fd_sc_hd__decap_3
XFILLER_0_13_314 VGND VGND VPWR VPWR sky130_fd_sc_hd__decap_3
XFILLER_0_14_9 VGND VGND VPWR VPWR sky130_fd_sc_hd__decap_3
XFILLER_0_14_12 VGND VGND VPWR VPWR sky130_fd_sc_hd__fill_2
XFILLER_0_14_29 VGND VGND VPWR VPWR sky130_fd_sc_hd__decap_3
XFILLER_0_14_32 VGND VGND VPWR VPWR sky130_fd_sc_hd__decap_3
XFILLER_0_14_35 VGND VGND VPWR VPWR sky130_fd_sc_hd__decap_3
XFILLER_0_14_38 VGND VGND VPWR VPWR sky130_fd_sc_hd__decap_3
XFILLER_0_14_41 VGND VGND VPWR VPWR sky130_fd_sc_hd__decap_3
XFILLER_0_14_44 VGND VGND VPWR VPWR sky130_fd_sc_hd__decap_3
XFILLER_0_14_47 VGND VGND VPWR VPWR sky130_fd_sc_hd__decap_3
XFILLER_0_14_50 VGND VGND VPWR VPWR sky130_fd_sc_hd__decap_3
XFILLER_0_14_53 VGND VGND VPWR VPWR sky130_fd_sc_hd__decap_3
XFILLER_0_14_62 VGND VGND VPWR VPWR sky130_fd_sc_hd__fill_2
XFILLER_0_14_104 VGND VGND VPWR VPWR sky130_fd_sc_hd__decap_3
XFILLER_0_14_107 VGND VGND VPWR VPWR sky130_fd_sc_hd__decap_3
XFILLER_0_14_110 VGND VGND VPWR VPWR sky130_fd_sc_hd__decap_3
XFILLER_0_14_113 VGND VGND VPWR VPWR sky130_fd_sc_hd__decap_3
XFILLER_0_14_116 VGND VGND VPWR VPWR sky130_fd_sc_hd__decap_3
XFILLER_0_14_119 VGND VGND VPWR VPWR sky130_fd_sc_hd__decap_3
XFILLER_0_14_122 VGND VGND VPWR VPWR sky130_fd_sc_hd__decap_3
XFILLER_0_14_125 VGND VGND VPWR VPWR sky130_fd_sc_hd__decap_3
XFILLER_0_14_128 VGND VGND VPWR VPWR sky130_fd_sc_hd__decap_3
XFILLER_0_14_131 VGND VGND VPWR VPWR sky130_fd_sc_hd__decap_3
XFILLER_0_14_134 VGND VGND VPWR VPWR sky130_fd_sc_hd__decap_3
XFILLER_0_14_137 VGND VGND VPWR VPWR sky130_fd_sc_hd__decap_3
XFILLER_0_14_141 VGND VGND VPWR VPWR sky130_fd_sc_hd__decap_3
XFILLER_0_14_144 VGND VGND VPWR VPWR sky130_fd_sc_hd__decap_3
XFILLER_0_14_147 VGND VGND VPWR VPWR sky130_fd_sc_hd__fill_1
XFILLER_0_14_188 VGND VGND VPWR VPWR sky130_fd_sc_hd__decap_3
XFILLER_0_14_191 VGND VGND VPWR VPWR sky130_fd_sc_hd__decap_3
XFILLER_0_14_194 VGND VGND VPWR VPWR sky130_fd_sc_hd__fill_2
XFILLER_0_14_213 VGND VGND VPWR VPWR sky130_fd_sc_hd__fill_1
XFILLER_0_14_230 VGND VGND VPWR VPWR sky130_fd_sc_hd__decap_3
XFILLER_0_14_249 VGND VGND VPWR VPWR sky130_fd_sc_hd__decap_3
XFILLER_0_14_253 VGND VGND VPWR VPWR sky130_fd_sc_hd__decap_3
XFILLER_0_14_256 VGND VGND VPWR VPWR sky130_fd_sc_hd__decap_3
XFILLER_0_14_259 VGND VGND VPWR VPWR sky130_fd_sc_hd__fill_1
XFILLER_0_14_296 VGND VGND VPWR VPWR sky130_fd_sc_hd__decap_3
XFILLER_0_14_299 VGND VGND VPWR VPWR sky130_fd_sc_hd__decap_3
XFILLER_0_14_302 VGND VGND VPWR VPWR sky130_fd_sc_hd__decap_3
XFILLER_0_14_305 VGND VGND VPWR VPWR sky130_fd_sc_hd__decap_3
XFILLER_0_14_309 VGND VGND VPWR VPWR sky130_fd_sc_hd__decap_3
XFILLER_0_14_312 VGND VGND VPWR VPWR sky130_fd_sc_hd__decap_3
XFILLER_0_14_315 VGND VGND VPWR VPWR sky130_fd_sc_hd__fill_2
XFILLER_0_15_3 VGND VGND VPWR VPWR sky130_fd_sc_hd__decap_3
XFILLER_0_15_6 VGND VGND VPWR VPWR sky130_fd_sc_hd__decap_3
XFILLER_0_15_9 VGND VGND VPWR VPWR sky130_fd_sc_hd__decap_3
XFILLER_0_15_12 VGND VGND VPWR VPWR sky130_fd_sc_hd__decap_3
XFILLER_0_15_15 VGND VGND VPWR VPWR sky130_fd_sc_hd__decap_3
XFILLER_0_15_20 VGND VGND VPWR VPWR sky130_fd_sc_hd__fill_2
XFILLER_0_15_44 VGND VGND VPWR VPWR sky130_fd_sc_hd__fill_2
XFILLER_0_15_48 VGND VGND VPWR VPWR sky130_fd_sc_hd__decap_3
XFILLER_0_15_51 VGND VGND VPWR VPWR sky130_fd_sc_hd__decap_3
XFILLER_0_15_54 VGND VGND VPWR VPWR sky130_fd_sc_hd__fill_2
XFILLER_0_15_57 VGND VGND VPWR VPWR sky130_fd_sc_hd__fill_2
XFILLER_0_15_110 VGND VGND VPWR VPWR sky130_fd_sc_hd__fill_2
XFILLER_0_15_113 VGND VGND VPWR VPWR sky130_fd_sc_hd__decap_3
XFILLER_0_15_116 VGND VGND VPWR VPWR sky130_fd_sc_hd__fill_2
XFILLER_0_15_134 VGND VGND VPWR VPWR sky130_fd_sc_hd__fill_1
XFILLER_0_15_155 VGND VGND VPWR VPWR sky130_fd_sc_hd__decap_3
XFILLER_0_15_158 VGND VGND VPWR VPWR sky130_fd_sc_hd__fill_2
XFILLER_0_15_196 VGND VGND VPWR VPWR sky130_fd_sc_hd__decap_3
XFILLER_0_15_199 VGND VGND VPWR VPWR sky130_fd_sc_hd__decap_3
XFILLER_0_15_222 VGND VGND VPWR VPWR sky130_fd_sc_hd__fill_2
XFILLER_0_15_225 VGND VGND VPWR VPWR sky130_fd_sc_hd__decap_3
XFILLER_0_15_228 VGND VGND VPWR VPWR sky130_fd_sc_hd__decap_3
XFILLER_0_15_231 VGND VGND VPWR VPWR sky130_fd_sc_hd__decap_3
XFILLER_0_15_234 VGND VGND VPWR VPWR sky130_fd_sc_hd__fill_1
XFILLER_0_15_255 VGND VGND VPWR VPWR sky130_fd_sc_hd__decap_3
XFILLER_0_15_258 VGND VGND VPWR VPWR sky130_fd_sc_hd__fill_1
XFILLER_0_15_279 VGND VGND VPWR VPWR sky130_fd_sc_hd__fill_1
XFILLER_0_15_301 VGND VGND VPWR VPWR sky130_fd_sc_hd__decap_3
XFILLER_0_15_304 VGND VGND VPWR VPWR sky130_fd_sc_hd__decap_3
XFILLER_0_15_307 VGND VGND VPWR VPWR sky130_fd_sc_hd__decap_3
XFILLER_0_15_310 VGND VGND VPWR VPWR sky130_fd_sc_hd__decap_3
XFILLER_0_15_313 VGND VGND VPWR VPWR sky130_fd_sc_hd__decap_3
XFILLER_0_15_316 VGND VGND VPWR VPWR sky130_fd_sc_hd__fill_1
XFILLER_0_16_3 VGND VGND VPWR VPWR sky130_fd_sc_hd__decap_3
XFILLER_0_16_6 VGND VGND VPWR VPWR sky130_fd_sc_hd__fill_1
XFILLER_0_16_50 VGND VGND VPWR VPWR sky130_fd_sc_hd__decap_3
XFILLER_0_16_53 VGND VGND VPWR VPWR sky130_fd_sc_hd__decap_3
XFILLER_0_16_56 VGND VGND VPWR VPWR sky130_fd_sc_hd__decap_3
XFILLER_0_16_59 VGND VGND VPWR VPWR sky130_fd_sc_hd__decap_3
XFILLER_0_16_62 VGND VGND VPWR VPWR sky130_fd_sc_hd__decap_3
XFILLER_0_16_82 VGND VGND VPWR VPWR sky130_fd_sc_hd__fill_2
XFILLER_0_16_101 VGND VGND VPWR VPWR sky130_fd_sc_hd__decap_3
XFILLER_0_16_141 VGND VGND VPWR VPWR sky130_fd_sc_hd__decap_3
XFILLER_0_16_144 VGND VGND VPWR VPWR sky130_fd_sc_hd__decap_3
XFILLER_0_16_147 VGND VGND VPWR VPWR sky130_fd_sc_hd__decap_3
XFILLER_0_16_150 VGND VGND VPWR VPWR sky130_fd_sc_hd__decap_3
XFILLER_0_16_153 VGND VGND VPWR VPWR sky130_fd_sc_hd__decap_3
XFILLER_0_16_192 VGND VGND VPWR VPWR sky130_fd_sc_hd__decap_3
XFILLER_0_16_195 VGND VGND VPWR VPWR sky130_fd_sc_hd__fill_1
XFILLER_0_16_237 VGND VGND VPWR VPWR sky130_fd_sc_hd__decap_3
XFILLER_0_16_240 VGND VGND VPWR VPWR sky130_fd_sc_hd__decap_3
XFILLER_0_16_243 VGND VGND VPWR VPWR sky130_fd_sc_hd__decap_3
XFILLER_0_16_246 VGND VGND VPWR VPWR sky130_fd_sc_hd__decap_3
XFILLER_0_16_249 VGND VGND VPWR VPWR sky130_fd_sc_hd__decap_3
XFILLER_0_16_269 VGND VGND VPWR VPWR sky130_fd_sc_hd__decap_3
XFILLER_0_16_280 VGND VGND VPWR VPWR sky130_fd_sc_hd__decap_3
XFILLER_0_16_303 VGND VGND VPWR VPWR sky130_fd_sc_hd__decap_3
XFILLER_0_16_306 VGND VGND VPWR VPWR sky130_fd_sc_hd__fill_2
XFILLER_0_16_309 VGND VGND VPWR VPWR sky130_fd_sc_hd__decap_3
XFILLER_0_16_312 VGND VGND VPWR VPWR sky130_fd_sc_hd__decap_3
XFILLER_0_16_315 VGND VGND VPWR VPWR sky130_fd_sc_hd__fill_2
XFILLER_0_17_3 VGND VGND VPWR VPWR sky130_fd_sc_hd__decap_3
XFILLER_0_17_6 VGND VGND VPWR VPWR sky130_fd_sc_hd__decap_3
XFILLER_0_17_9 VGND VGND VPWR VPWR sky130_fd_sc_hd__decap_3
XFILLER_0_17_12 VGND VGND VPWR VPWR sky130_fd_sc_hd__fill_2
XFILLER_0_17_57 VGND VGND VPWR VPWR sky130_fd_sc_hd__decap_3
XFILLER_0_17_60 VGND VGND VPWR VPWR sky130_fd_sc_hd__fill_2
XFILLER_0_17_64 VGND VGND VPWR VPWR sky130_fd_sc_hd__decap_3
XFILLER_0_17_67 VGND VGND VPWR VPWR sky130_fd_sc_hd__decap_3
XFILLER_0_17_70 VGND VGND VPWR VPWR sky130_fd_sc_hd__fill_1
XFILLER_0_17_93 VGND VGND VPWR VPWR sky130_fd_sc_hd__decap_3
XFILLER_0_17_133 VGND VGND VPWR VPWR sky130_fd_sc_hd__fill_1
XFILLER_0_17_166 VGND VGND VPWR VPWR sky130_fd_sc_hd__fill_2
XFILLER_0_17_249 VGND VGND VPWR VPWR sky130_fd_sc_hd__decap_3
XFILLER_0_17_252 VGND VGND VPWR VPWR sky130_fd_sc_hd__decap_3
XFILLER_0_17_255 VGND VGND VPWR VPWR sky130_fd_sc_hd__decap_3
XFILLER_0_17_258 VGND VGND VPWR VPWR sky130_fd_sc_hd__decap_3
XFILLER_0_17_261 VGND VGND VPWR VPWR sky130_fd_sc_hd__decap_3
XFILLER_0_17_281 VGND VGND VPWR VPWR sky130_fd_sc_hd__decap_3
XFILLER_0_17_284 VGND VGND VPWR VPWR sky130_fd_sc_hd__decap_3
XFILLER_0_17_287 VGND VGND VPWR VPWR sky130_fd_sc_hd__fill_1
XFILLER_0_17_308 VGND VGND VPWR VPWR sky130_fd_sc_hd__decap_3
XFILLER_0_17_311 VGND VGND VPWR VPWR sky130_fd_sc_hd__decap_3
XFILLER_0_17_314 VGND VGND VPWR VPWR sky130_fd_sc_hd__decap_3
XFILLER_0_18_3 VGND VGND VPWR VPWR sky130_fd_sc_hd__decap_3
XFILLER_0_18_6 VGND VGND VPWR VPWR sky130_fd_sc_hd__decap_3
XFILLER_0_18_9 VGND VGND VPWR VPWR sky130_fd_sc_hd__decap_3
XFILLER_0_18_12 VGND VGND VPWR VPWR sky130_fd_sc_hd__decap_3
XFILLER_0_18_15 VGND VGND VPWR VPWR sky130_fd_sc_hd__decap_3
XFILLER_0_18_18 VGND VGND VPWR VPWR sky130_fd_sc_hd__fill_1
XFILLER_0_18_62 VGND VGND VPWR VPWR sky130_fd_sc_hd__fill_2
XFILLER_0_18_85 VGND VGND VPWR VPWR sky130_fd_sc_hd__fill_2
XFILLER_0_18_123 VGND VGND VPWR VPWR sky130_fd_sc_hd__fill_1
XFILLER_0_18_161 VGND VGND VPWR VPWR sky130_fd_sc_hd__decap_3
XFILLER_0_18_164 VGND VGND VPWR VPWR sky130_fd_sc_hd__decap_3
XFILLER_0_18_167 VGND VGND VPWR VPWR sky130_fd_sc_hd__decap_3
XFILLER_0_18_170 VGND VGND VPWR VPWR sky130_fd_sc_hd__decap_3
XFILLER_0_18_173 VGND VGND VPWR VPWR sky130_fd_sc_hd__decap_3
XFILLER_0_18_176 VGND VGND VPWR VPWR sky130_fd_sc_hd__decap_3
XFILLER_0_18_179 VGND VGND VPWR VPWR sky130_fd_sc_hd__decap_3
XFILLER_0_18_182 VGND VGND VPWR VPWR sky130_fd_sc_hd__decap_3
XFILLER_0_18_185 VGND VGND VPWR VPWR sky130_fd_sc_hd__fill_2
XFILLER_0_18_195 VGND VGND VPWR VPWR sky130_fd_sc_hd__fill_1
XFILLER_0_18_197 VGND VGND VPWR VPWR sky130_fd_sc_hd__fill_2
XFILLER_0_18_228 VGND VGND VPWR VPWR sky130_fd_sc_hd__decap_3
XFILLER_0_18_282 VGND VGND VPWR VPWR sky130_fd_sc_hd__decap_3
XFILLER_0_18_285 VGND VGND VPWR VPWR sky130_fd_sc_hd__decap_3
XFILLER_0_18_309 VGND VGND VPWR VPWR sky130_fd_sc_hd__decap_3
XFILLER_0_18_312 VGND VGND VPWR VPWR sky130_fd_sc_hd__decap_3
XFILLER_0_18_315 VGND VGND VPWR VPWR sky130_fd_sc_hd__fill_2
XFILLER_0_19_9 VGND VGND VPWR VPWR sky130_fd_sc_hd__decap_3
XFILLER_0_19_12 VGND VGND VPWR VPWR sky130_fd_sc_hd__decap_3
XFILLER_0_19_15 VGND VGND VPWR VPWR sky130_fd_sc_hd__decap_3
XFILLER_0_19_18 VGND VGND VPWR VPWR sky130_fd_sc_hd__fill_2
XFILLER_0_19_53 VGND VGND VPWR VPWR sky130_fd_sc_hd__decap_3
XFILLER_0_19_63 VGND VGND VPWR VPWR sky130_fd_sc_hd__decap_3
XFILLER_0_19_66 VGND VGND VPWR VPWR sky130_fd_sc_hd__decap_3
XFILLER_0_19_69 VGND VGND VPWR VPWR sky130_fd_sc_hd__decap_3
XFILLER_0_19_91 VGND VGND VPWR VPWR sky130_fd_sc_hd__decap_3
XFILLER_0_19_94 VGND VGND VPWR VPWR sky130_fd_sc_hd__fill_2
XFILLER_0_19_119 VGND VGND VPWR VPWR sky130_fd_sc_hd__decap_3
XFILLER_0_19_122 VGND VGND VPWR VPWR sky130_fd_sc_hd__decap_3
XFILLER_0_19_125 VGND VGND VPWR VPWR sky130_fd_sc_hd__fill_1
XFILLER_0_19_146 VGND VGND VPWR VPWR sky130_fd_sc_hd__fill_2
XFILLER_0_19_169 VGND VGND VPWR VPWR sky130_fd_sc_hd__decap_3
XFILLER_0_19_172 VGND VGND VPWR VPWR sky130_fd_sc_hd__decap_3
XFILLER_0_19_175 VGND VGND VPWR VPWR sky130_fd_sc_hd__fill_2
XFILLER_0_19_219 VGND VGND VPWR VPWR sky130_fd_sc_hd__decap_3
XFILLER_0_19_222 VGND VGND VPWR VPWR sky130_fd_sc_hd__fill_2
XFILLER_0_19_267 VGND VGND VPWR VPWR sky130_fd_sc_hd__decap_3
XFILLER_0_19_270 VGND VGND VPWR VPWR sky130_fd_sc_hd__decap_3
XFILLER_0_19_273 VGND VGND VPWR VPWR sky130_fd_sc_hd__decap_3
XFILLER_0_19_276 VGND VGND VPWR VPWR sky130_fd_sc_hd__decap_3
XFILLER_0_19_279 VGND VGND VPWR VPWR sky130_fd_sc_hd__fill_1
XFILLER_0_19_289 VGND VGND VPWR VPWR sky130_fd_sc_hd__fill_1
XFILLER_0_19_310 VGND VGND VPWR VPWR sky130_fd_sc_hd__decap_3
XFILLER_0_19_313 VGND VGND VPWR VPWR sky130_fd_sc_hd__decap_3
XFILLER_0_19_316 VGND VGND VPWR VPWR sky130_fd_sc_hd__fill_1
XFILLER_0_20_3 VGND VGND VPWR VPWR sky130_fd_sc_hd__decap_3
XFILLER_0_20_6 VGND VGND VPWR VPWR sky130_fd_sc_hd__decap_3
XFILLER_0_20_9 VGND VGND VPWR VPWR sky130_fd_sc_hd__decap_3
XFILLER_0_20_12 VGND VGND VPWR VPWR sky130_fd_sc_hd__decap_3
XFILLER_0_20_15 VGND VGND VPWR VPWR sky130_fd_sc_hd__decap_3
XFILLER_0_20_18 VGND VGND VPWR VPWR sky130_fd_sc_hd__decap_3
XFILLER_0_20_21 VGND VGND VPWR VPWR sky130_fd_sc_hd__decap_3
XFILLER_0_20_26 VGND VGND VPWR VPWR sky130_fd_sc_hd__fill_2
XFILLER_0_20_45 VGND VGND VPWR VPWR sky130_fd_sc_hd__fill_2
XFILLER_0_20_49 VGND VGND VPWR VPWR sky130_fd_sc_hd__decap_3
XFILLER_0_20_52 VGND VGND VPWR VPWR sky130_fd_sc_hd__decap_3
XFILLER_0_20_55 VGND VGND VPWR VPWR sky130_fd_sc_hd__decap_3
XFILLER_0_20_58 VGND VGND VPWR VPWR sky130_fd_sc_hd__decap_3
XFILLER_0_20_61 VGND VGND VPWR VPWR sky130_fd_sc_hd__decap_3
XFILLER_0_20_64 VGND VGND VPWR VPWR sky130_fd_sc_hd__decap_3
XFILLER_0_20_67 VGND VGND VPWR VPWR sky130_fd_sc_hd__decap_3
XFILLER_0_20_70 VGND VGND VPWR VPWR sky130_fd_sc_hd__decap_3
XFILLER_0_20_73 VGND VGND VPWR VPWR sky130_fd_sc_hd__decap_3
XFILLER_0_20_76 VGND VGND VPWR VPWR sky130_fd_sc_hd__decap_3
XFILLER_0_20_79 VGND VGND VPWR VPWR sky130_fd_sc_hd__decap_3
XFILLER_0_20_82 VGND VGND VPWR VPWR sky130_fd_sc_hd__fill_2
XFILLER_0_20_85 VGND VGND VPWR VPWR sky130_fd_sc_hd__decap_3
XFILLER_0_20_88 VGND VGND VPWR VPWR sky130_fd_sc_hd__decap_3
XFILLER_0_20_91 VGND VGND VPWR VPWR sky130_fd_sc_hd__decap_3
XFILLER_0_20_94 VGND VGND VPWR VPWR sky130_fd_sc_hd__decap_3
XFILLER_0_20_97 VGND VGND VPWR VPWR sky130_fd_sc_hd__fill_1
XFILLER_0_20_155 VGND VGND VPWR VPWR sky130_fd_sc_hd__decap_3
XFILLER_0_20_158 VGND VGND VPWR VPWR sky130_fd_sc_hd__fill_1
XFILLER_0_20_197 VGND VGND VPWR VPWR sky130_fd_sc_hd__fill_1
XFILLER_0_20_280 VGND VGND VPWR VPWR sky130_fd_sc_hd__decap_3
XFILLER_0_20_283 VGND VGND VPWR VPWR sky130_fd_sc_hd__decap_3
XFILLER_0_20_286 VGND VGND VPWR VPWR sky130_fd_sc_hd__fill_1
XFILLER_0_20_307 VGND VGND VPWR VPWR sky130_fd_sc_hd__fill_1
XFILLER_0_20_309 VGND VGND VPWR VPWR sky130_fd_sc_hd__decap_3
XFILLER_0_20_312 VGND VGND VPWR VPWR sky130_fd_sc_hd__decap_3
XFILLER_0_20_315 VGND VGND VPWR VPWR sky130_fd_sc_hd__fill_2
XFILLER_0_21_3 VGND VGND VPWR VPWR sky130_fd_sc_hd__decap_3
XFILLER_0_21_6 VGND VGND VPWR VPWR sky130_fd_sc_hd__fill_1
XFILLER_0_21_55 VGND VGND VPWR VPWR sky130_fd_sc_hd__fill_1
XFILLER_0_21_57 VGND VGND VPWR VPWR sky130_fd_sc_hd__decap_3
XFILLER_0_21_60 VGND VGND VPWR VPWR sky130_fd_sc_hd__decap_3
XFILLER_0_21_63 VGND VGND VPWR VPWR sky130_fd_sc_hd__decap_3
XFILLER_0_21_66 VGND VGND VPWR VPWR sky130_fd_sc_hd__decap_3
XFILLER_0_21_69 VGND VGND VPWR VPWR sky130_fd_sc_hd__fill_1
XFILLER_0_21_86 VGND VGND VPWR VPWR sky130_fd_sc_hd__decap_3
XFILLER_0_21_89 VGND VGND VPWR VPWR sky130_fd_sc_hd__decap_3
XFILLER_0_21_137 VGND VGND VPWR VPWR sky130_fd_sc_hd__decap_3
XFILLER_0_21_140 VGND VGND VPWR VPWR sky130_fd_sc_hd__fill_1
XFILLER_0_21_162 VGND VGND VPWR VPWR sky130_fd_sc_hd__decap_3
XFILLER_0_21_165 VGND VGND VPWR VPWR sky130_fd_sc_hd__decap_3
XFILLER_0_21_169 VGND VGND VPWR VPWR sky130_fd_sc_hd__fill_2
XFILLER_0_21_179 VGND VGND VPWR VPWR sky130_fd_sc_hd__fill_2
XFILLER_0_21_187 VGND VGND VPWR VPWR sky130_fd_sc_hd__fill_1
XFILLER_0_21_208 VGND VGND VPWR VPWR sky130_fd_sc_hd__decap_3
XFILLER_0_21_269 VGND VGND VPWR VPWR sky130_fd_sc_hd__decap_3
XFILLER_0_21_272 VGND VGND VPWR VPWR sky130_fd_sc_hd__decap_3
XFILLER_0_21_275 VGND VGND VPWR VPWR sky130_fd_sc_hd__decap_3
XFILLER_0_21_278 VGND VGND VPWR VPWR sky130_fd_sc_hd__fill_2
XFILLER_0_21_313 VGND VGND VPWR VPWR sky130_fd_sc_hd__decap_3
XFILLER_0_21_316 VGND VGND VPWR VPWR sky130_fd_sc_hd__fill_1
XFILLER_0_22_3 VGND VGND VPWR VPWR sky130_fd_sc_hd__decap_3
XFILLER_0_22_6 VGND VGND VPWR VPWR sky130_fd_sc_hd__decap_3
XFILLER_0_22_9 VGND VGND VPWR VPWR sky130_fd_sc_hd__decap_3
XFILLER_0_22_29 VGND VGND VPWR VPWR sky130_fd_sc_hd__decap_3
XFILLER_0_22_32 VGND VGND VPWR VPWR sky130_fd_sc_hd__decap_3
XFILLER_0_22_35 VGND VGND VPWR VPWR sky130_fd_sc_hd__fill_1
XFILLER_0_22_128 VGND VGND VPWR VPWR sky130_fd_sc_hd__fill_1
XFILLER_0_22_137 VGND VGND VPWR VPWR sky130_fd_sc_hd__decap_3
XFILLER_0_22_147 VGND VGND VPWR VPWR sky130_fd_sc_hd__decap_3
XFILLER_0_22_150 VGND VGND VPWR VPWR sky130_fd_sc_hd__decap_3
XFILLER_0_22_153 VGND VGND VPWR VPWR sky130_fd_sc_hd__decap_3
XFILLER_0_22_156 VGND VGND VPWR VPWR sky130_fd_sc_hd__fill_1
XFILLER_0_22_178 VGND VGND VPWR VPWR sky130_fd_sc_hd__decap_3
XFILLER_0_22_181 VGND VGND VPWR VPWR sky130_fd_sc_hd__decap_3
XFILLER_0_22_184 VGND VGND VPWR VPWR sky130_fd_sc_hd__decap_3
XFILLER_0_22_195 VGND VGND VPWR VPWR sky130_fd_sc_hd__fill_1
XFILLER_0_22_197 VGND VGND VPWR VPWR sky130_fd_sc_hd__decap_3
XFILLER_0_22_200 VGND VGND VPWR VPWR sky130_fd_sc_hd__fill_2
XFILLER_0_22_235 VGND VGND VPWR VPWR sky130_fd_sc_hd__fill_2
XFILLER_0_22_274 VGND VGND VPWR VPWR sky130_fd_sc_hd__decap_3
XFILLER_0_22_277 VGND VGND VPWR VPWR sky130_fd_sc_hd__decap_3
XFILLER_0_22_309 VGND VGND VPWR VPWR sky130_fd_sc_hd__decap_3
XFILLER_0_22_312 VGND VGND VPWR VPWR sky130_fd_sc_hd__decap_3
XFILLER_0_22_315 VGND VGND VPWR VPWR sky130_fd_sc_hd__fill_2
XFILLER_0_23_3 VGND VGND VPWR VPWR sky130_fd_sc_hd__decap_3
XFILLER_0_23_6 VGND VGND VPWR VPWR sky130_fd_sc_hd__decap_3
XFILLER_0_23_9 VGND VGND VPWR VPWR sky130_fd_sc_hd__decap_3
XFILLER_0_23_12 VGND VGND VPWR VPWR sky130_fd_sc_hd__fill_1
XFILLER_0_23_29 VGND VGND VPWR VPWR sky130_fd_sc_hd__decap_3
XFILLER_0_23_48 VGND VGND VPWR VPWR sky130_fd_sc_hd__decap_3
XFILLER_0_23_51 VGND VGND VPWR VPWR sky130_fd_sc_hd__decap_3
XFILLER_0_23_54 VGND VGND VPWR VPWR sky130_fd_sc_hd__fill_2
XFILLER_0_23_73 VGND VGND VPWR VPWR sky130_fd_sc_hd__decap_3
XFILLER_0_23_92 VGND VGND VPWR VPWR sky130_fd_sc_hd__fill_2
XFILLER_0_23_108 VGND VGND VPWR VPWR sky130_fd_sc_hd__decap_3
XFILLER_0_23_111 VGND VGND VPWR VPWR sky130_fd_sc_hd__fill_1
XFILLER_0_23_113 VGND VGND VPWR VPWR sky130_fd_sc_hd__decap_3
XFILLER_0_23_116 VGND VGND VPWR VPWR sky130_fd_sc_hd__fill_2
XFILLER_0_23_160 VGND VGND VPWR VPWR sky130_fd_sc_hd__decap_3
XFILLER_0_23_163 VGND VGND VPWR VPWR sky130_fd_sc_hd__decap_3
XFILLER_0_23_166 VGND VGND VPWR VPWR sky130_fd_sc_hd__fill_2
XFILLER_0_23_169 VGND VGND VPWR VPWR sky130_fd_sc_hd__decap_3
XFILLER_0_23_172 VGND VGND VPWR VPWR sky130_fd_sc_hd__decap_3
XFILLER_0_23_216 VGND VGND VPWR VPWR sky130_fd_sc_hd__decap_3
XFILLER_0_23_240 VGND VGND VPWR VPWR sky130_fd_sc_hd__fill_2
XFILLER_0_23_263 VGND VGND VPWR VPWR sky130_fd_sc_hd__fill_1
XFILLER_0_23_281 VGND VGND VPWR VPWR sky130_fd_sc_hd__fill_1
XFILLER_0_23_310 VGND VGND VPWR VPWR sky130_fd_sc_hd__decap_3
XFILLER_0_23_313 VGND VGND VPWR VPWR sky130_fd_sc_hd__decap_3
XFILLER_0_23_316 VGND VGND VPWR VPWR sky130_fd_sc_hd__fill_1
XFILLER_0_24_3 VGND VGND VPWR VPWR sky130_fd_sc_hd__decap_3
XFILLER_0_24_6 VGND VGND VPWR VPWR sky130_fd_sc_hd__fill_1
XFILLER_0_24_23 VGND VGND VPWR VPWR sky130_fd_sc_hd__decap_3
XFILLER_0_24_26 VGND VGND VPWR VPWR sky130_fd_sc_hd__fill_2
XFILLER_0_24_29 VGND VGND VPWR VPWR sky130_fd_sc_hd__decap_3
XFILLER_0_24_32 VGND VGND VPWR VPWR sky130_fd_sc_hd__decap_3
XFILLER_0_24_35 VGND VGND VPWR VPWR sky130_fd_sc_hd__decap_3
XFILLER_0_24_38 VGND VGND VPWR VPWR sky130_fd_sc_hd__decap_3
XFILLER_0_24_41 VGND VGND VPWR VPWR sky130_fd_sc_hd__decap_3
XFILLER_0_24_44 VGND VGND VPWR VPWR sky130_fd_sc_hd__decap_3
XFILLER_0_24_47 VGND VGND VPWR VPWR sky130_fd_sc_hd__fill_1
XFILLER_0_24_64 VGND VGND VPWR VPWR sky130_fd_sc_hd__decap_3
XFILLER_0_24_67 VGND VGND VPWR VPWR sky130_fd_sc_hd__decap_3
XFILLER_0_24_70 VGND VGND VPWR VPWR sky130_fd_sc_hd__decap_3
XFILLER_0_24_73 VGND VGND VPWR VPWR sky130_fd_sc_hd__decap_3
XFILLER_0_24_76 VGND VGND VPWR VPWR sky130_fd_sc_hd__decap_3
XFILLER_0_24_79 VGND VGND VPWR VPWR sky130_fd_sc_hd__decap_3
XFILLER_0_24_82 VGND VGND VPWR VPWR sky130_fd_sc_hd__fill_2
XFILLER_0_24_108 VGND VGND VPWR VPWR sky130_fd_sc_hd__decap_3
XFILLER_0_24_111 VGND VGND VPWR VPWR sky130_fd_sc_hd__fill_2
XFILLER_0_24_133 VGND VGND VPWR VPWR sky130_fd_sc_hd__decap_3
XFILLER_0_24_136 VGND VGND VPWR VPWR sky130_fd_sc_hd__decap_3
XFILLER_0_24_139 VGND VGND VPWR VPWR sky130_fd_sc_hd__fill_1
XFILLER_0_24_141 VGND VGND VPWR VPWR sky130_fd_sc_hd__fill_1
XFILLER_0_24_171 VGND VGND VPWR VPWR sky130_fd_sc_hd__decap_3
XFILLER_0_24_174 VGND VGND VPWR VPWR sky130_fd_sc_hd__decap_3
XFILLER_0_24_193 VGND VGND VPWR VPWR sky130_fd_sc_hd__decap_3
XFILLER_0_24_197 VGND VGND VPWR VPWR sky130_fd_sc_hd__fill_2
XFILLER_0_24_207 VGND VGND VPWR VPWR sky130_fd_sc_hd__decap_3
XFILLER_0_24_210 VGND VGND VPWR VPWR sky130_fd_sc_hd__decap_3
XFILLER_0_24_213 VGND VGND VPWR VPWR sky130_fd_sc_hd__fill_1
XFILLER_0_24_277 VGND VGND VPWR VPWR sky130_fd_sc_hd__decap_3
XFILLER_0_24_309 VGND VGND VPWR VPWR sky130_fd_sc_hd__decap_3
XFILLER_0_24_312 VGND VGND VPWR VPWR sky130_fd_sc_hd__decap_3
XFILLER_0_24_315 VGND VGND VPWR VPWR sky130_fd_sc_hd__fill_2
XFILLER_0_25_3 VGND VGND VPWR VPWR sky130_fd_sc_hd__decap_3
XFILLER_0_25_6 VGND VGND VPWR VPWR sky130_fd_sc_hd__fill_1
XFILLER_0_25_39 VGND VGND VPWR VPWR sky130_fd_sc_hd__fill_1
XFILLER_0_25_73 VGND VGND VPWR VPWR sky130_fd_sc_hd__decap_3
XFILLER_0_25_76 VGND VGND VPWR VPWR sky130_fd_sc_hd__fill_2
XFILLER_0_25_111 VGND VGND VPWR VPWR sky130_fd_sc_hd__fill_1
XFILLER_0_25_152 VGND VGND VPWR VPWR sky130_fd_sc_hd__decap_3
XFILLER_0_25_163 VGND VGND VPWR VPWR sky130_fd_sc_hd__decap_3
XFILLER_0_25_166 VGND VGND VPWR VPWR sky130_fd_sc_hd__fill_2
XFILLER_0_25_169 VGND VGND VPWR VPWR sky130_fd_sc_hd__decap_3
XFILLER_0_25_172 VGND VGND VPWR VPWR sky130_fd_sc_hd__decap_3
XFILLER_0_25_175 VGND VGND VPWR VPWR sky130_fd_sc_hd__decap_3
XFILLER_0_25_178 VGND VGND VPWR VPWR sky130_fd_sc_hd__decap_3
XFILLER_0_25_197 VGND VGND VPWR VPWR sky130_fd_sc_hd__decap_3
XFILLER_0_25_200 VGND VGND VPWR VPWR sky130_fd_sc_hd__decap_3
XFILLER_0_25_203 VGND VGND VPWR VPWR sky130_fd_sc_hd__decap_3
XFILLER_0_25_206 VGND VGND VPWR VPWR sky130_fd_sc_hd__decap_3
XFILLER_0_25_209 VGND VGND VPWR VPWR sky130_fd_sc_hd__decap_3
XFILLER_0_25_212 VGND VGND VPWR VPWR sky130_fd_sc_hd__decap_3
XFILLER_0_25_215 VGND VGND VPWR VPWR sky130_fd_sc_hd__fill_2
XFILLER_0_25_284 VGND VGND VPWR VPWR sky130_fd_sc_hd__decap_3
XFILLER_0_25_287 VGND VGND VPWR VPWR sky130_fd_sc_hd__fill_1
XFILLER_0_25_308 VGND VGND VPWR VPWR sky130_fd_sc_hd__decap_3
XFILLER_0_25_311 VGND VGND VPWR VPWR sky130_fd_sc_hd__decap_3
XFILLER_0_25_314 VGND VGND VPWR VPWR sky130_fd_sc_hd__decap_3
XFILLER_0_26_3 VGND VGND VPWR VPWR sky130_fd_sc_hd__decap_3
XFILLER_0_26_6 VGND VGND VPWR VPWR sky130_fd_sc_hd__decap_3
XFILLER_0_26_9 VGND VGND VPWR VPWR sky130_fd_sc_hd__decap_3
XFILLER_0_26_45 VGND VGND VPWR VPWR sky130_fd_sc_hd__fill_2
XFILLER_0_26_79 VGND VGND VPWR VPWR sky130_fd_sc_hd__fill_2
XFILLER_0_26_132 VGND VGND VPWR VPWR sky130_fd_sc_hd__decap_3
XFILLER_0_26_135 VGND VGND VPWR VPWR sky130_fd_sc_hd__decap_3
XFILLER_0_26_138 VGND VGND VPWR VPWR sky130_fd_sc_hd__fill_2
XFILLER_0_26_141 VGND VGND VPWR VPWR sky130_fd_sc_hd__decap_3
XFILLER_0_26_167 VGND VGND VPWR VPWR sky130_fd_sc_hd__decap_3
XFILLER_0_26_170 VGND VGND VPWR VPWR sky130_fd_sc_hd__decap_3
XFILLER_0_26_173 VGND VGND VPWR VPWR sky130_fd_sc_hd__decap_3
XFILLER_0_26_206 VGND VGND VPWR VPWR sky130_fd_sc_hd__fill_2
XFILLER_0_26_211 VGND VGND VPWR VPWR sky130_fd_sc_hd__fill_2
XFILLER_0_26_266 VGND VGND VPWR VPWR sky130_fd_sc_hd__fill_1
XFILLER_0_26_299 VGND VGND VPWR VPWR sky130_fd_sc_hd__decap_3
XFILLER_0_26_302 VGND VGND VPWR VPWR sky130_fd_sc_hd__decap_3
XFILLER_0_26_305 VGND VGND VPWR VPWR sky130_fd_sc_hd__decap_3
XFILLER_0_26_309 VGND VGND VPWR VPWR sky130_fd_sc_hd__decap_3
XFILLER_0_26_312 VGND VGND VPWR VPWR sky130_fd_sc_hd__decap_3
XFILLER_0_26_315 VGND VGND VPWR VPWR sky130_fd_sc_hd__fill_2
XFILLER_0_27_3 VGND VGND VPWR VPWR sky130_fd_sc_hd__decap_3
XFILLER_0_27_6 VGND VGND VPWR VPWR sky130_fd_sc_hd__decap_3
XFILLER_0_27_9 VGND VGND VPWR VPWR sky130_fd_sc_hd__decap_3
XFILLER_0_27_12 VGND VGND VPWR VPWR sky130_fd_sc_hd__fill_1
XFILLER_0_27_45 VGND VGND VPWR VPWR sky130_fd_sc_hd__decap_3
XFILLER_0_27_48 VGND VGND VPWR VPWR sky130_fd_sc_hd__decap_3
XFILLER_0_27_51 VGND VGND VPWR VPWR sky130_fd_sc_hd__decap_3
XFILLER_0_27_54 VGND VGND VPWR VPWR sky130_fd_sc_hd__fill_2
XFILLER_0_27_60 VGND VGND VPWR VPWR sky130_fd_sc_hd__decap_3
XFILLER_0_27_63 VGND VGND VPWR VPWR sky130_fd_sc_hd__decap_3
XFILLER_0_27_80 VGND VGND VPWR VPWR sky130_fd_sc_hd__fill_2
XFILLER_0_27_110 VGND VGND VPWR VPWR sky130_fd_sc_hd__fill_2
XFILLER_0_27_116 VGND VGND VPWR VPWR sky130_fd_sc_hd__fill_2
XFILLER_0_27_138 VGND VGND VPWR VPWR sky130_fd_sc_hd__fill_2
XFILLER_0_27_163 VGND VGND VPWR VPWR sky130_fd_sc_hd__decap_3
XFILLER_0_27_166 VGND VGND VPWR VPWR sky130_fd_sc_hd__fill_2
XFILLER_0_27_169 VGND VGND VPWR VPWR sky130_fd_sc_hd__decap_3
XFILLER_0_27_172 VGND VGND VPWR VPWR sky130_fd_sc_hd__fill_2
XFILLER_0_27_194 VGND VGND VPWR VPWR sky130_fd_sc_hd__decap_3
XFILLER_0_27_197 VGND VGND VPWR VPWR sky130_fd_sc_hd__fill_2
XFILLER_0_27_297 VGND VGND VPWR VPWR sky130_fd_sc_hd__decap_3
XFILLER_0_27_300 VGND VGND VPWR VPWR sky130_fd_sc_hd__decap_3
XFILLER_0_27_303 VGND VGND VPWR VPWR sky130_fd_sc_hd__decap_3
XFILLER_0_27_306 VGND VGND VPWR VPWR sky130_fd_sc_hd__decap_3
XFILLER_0_27_309 VGND VGND VPWR VPWR sky130_fd_sc_hd__decap_3
XFILLER_0_27_312 VGND VGND VPWR VPWR sky130_fd_sc_hd__decap_3
XFILLER_0_27_315 VGND VGND VPWR VPWR sky130_fd_sc_hd__fill_2
XFILLER_0_28_3 VGND VGND VPWR VPWR sky130_fd_sc_hd__decap_3
XFILLER_0_28_6 VGND VGND VPWR VPWR sky130_fd_sc_hd__decap_3
XFILLER_0_28_9 VGND VGND VPWR VPWR sky130_fd_sc_hd__fill_1
XFILLER_0_28_26 VGND VGND VPWR VPWR sky130_fd_sc_hd__fill_2
XFILLER_0_28_45 VGND VGND VPWR VPWR sky130_fd_sc_hd__fill_2
XFILLER_0_28_53 VGND VGND VPWR VPWR sky130_fd_sc_hd__decap_3
XFILLER_0_28_56 VGND VGND VPWR VPWR sky130_fd_sc_hd__fill_2
XFILLER_0_28_74 VGND VGND VPWR VPWR sky130_fd_sc_hd__decap_3
XFILLER_0_28_77 VGND VGND VPWR VPWR sky130_fd_sc_hd__decap_3
XFILLER_0_28_80 VGND VGND VPWR VPWR sky130_fd_sc_hd__decap_3
XFILLER_0_28_83 VGND VGND VPWR VPWR sky130_fd_sc_hd__fill_1
XFILLER_0_28_85 VGND VGND VPWR VPWR sky130_fd_sc_hd__fill_2
XFILLER_0_28_114 VGND VGND VPWR VPWR sky130_fd_sc_hd__decap_3
XFILLER_0_28_117 VGND VGND VPWR VPWR sky130_fd_sc_hd__decap_3
XFILLER_0_28_120 VGND VGND VPWR VPWR sky130_fd_sc_hd__decap_3
XFILLER_0_28_123 VGND VGND VPWR VPWR sky130_fd_sc_hd__fill_1
XFILLER_0_28_157 VGND VGND VPWR VPWR sky130_fd_sc_hd__fill_2
XFILLER_0_28_167 VGND VGND VPWR VPWR sky130_fd_sc_hd__decap_3
XFILLER_0_28_190 VGND VGND VPWR VPWR sky130_fd_sc_hd__decap_3
XFILLER_0_28_193 VGND VGND VPWR VPWR sky130_fd_sc_hd__decap_3
XFILLER_0_28_261 VGND VGND VPWR VPWR sky130_fd_sc_hd__fill_2
XFILLER_0_28_307 VGND VGND VPWR VPWR sky130_fd_sc_hd__fill_1
XFILLER_0_28_309 VGND VGND VPWR VPWR sky130_fd_sc_hd__decap_3
XFILLER_0_28_312 VGND VGND VPWR VPWR sky130_fd_sc_hd__decap_3
XFILLER_0_28_315 VGND VGND VPWR VPWR sky130_fd_sc_hd__fill_2
XFILLER_0_29_3 VGND VGND VPWR VPWR sky130_fd_sc_hd__decap_3
XFILLER_0_29_6 VGND VGND VPWR VPWR sky130_fd_sc_hd__decap_3
XFILLER_0_29_9 VGND VGND VPWR VPWR sky130_fd_sc_hd__decap_3
XFILLER_0_29_12 VGND VGND VPWR VPWR sky130_fd_sc_hd__decap_3
XFILLER_0_29_15 VGND VGND VPWR VPWR sky130_fd_sc_hd__decap_3
XFILLER_0_29_57 VGND VGND VPWR VPWR sky130_fd_sc_hd__decap_3
XFILLER_0_29_60 VGND VGND VPWR VPWR sky130_fd_sc_hd__fill_2
XFILLER_0_29_105 VGND VGND VPWR VPWR sky130_fd_sc_hd__decap_3
XFILLER_0_29_108 VGND VGND VPWR VPWR sky130_fd_sc_hd__decap_3
XFILLER_0_29_111 VGND VGND VPWR VPWR sky130_fd_sc_hd__fill_1
XFILLER_0_29_113 VGND VGND VPWR VPWR sky130_fd_sc_hd__decap_3
XFILLER_0_29_116 VGND VGND VPWR VPWR sky130_fd_sc_hd__decap_3
XFILLER_0_29_119 VGND VGND VPWR VPWR sky130_fd_sc_hd__fill_2
XFILLER_0_29_137 VGND VGND VPWR VPWR sky130_fd_sc_hd__fill_2
XFILLER_0_29_185 VGND VGND VPWR VPWR sky130_fd_sc_hd__decap_3
XFILLER_0_29_188 VGND VGND VPWR VPWR sky130_fd_sc_hd__decap_3
XFILLER_0_29_191 VGND VGND VPWR VPWR sky130_fd_sc_hd__decap_3
XFILLER_0_29_194 VGND VGND VPWR VPWR sky130_fd_sc_hd__decap_3
XFILLER_0_29_197 VGND VGND VPWR VPWR sky130_fd_sc_hd__decap_3
XFILLER_0_29_200 VGND VGND VPWR VPWR sky130_fd_sc_hd__fill_1
XFILLER_0_29_225 VGND VGND VPWR VPWR sky130_fd_sc_hd__fill_1
XFILLER_0_29_239 VGND VGND VPWR VPWR sky130_fd_sc_hd__fill_1
XFILLER_0_29_278 VGND VGND VPWR VPWR sky130_fd_sc_hd__fill_2
XFILLER_0_29_289 VGND VGND VPWR VPWR sky130_fd_sc_hd__decap_3
XFILLER_0_29_292 VGND VGND VPWR VPWR sky130_fd_sc_hd__decap_3
XFILLER_0_29_295 VGND VGND VPWR VPWR sky130_fd_sc_hd__decap_3
XFILLER_0_29_298 VGND VGND VPWR VPWR sky130_fd_sc_hd__decap_3
XFILLER_0_29_301 VGND VGND VPWR VPWR sky130_fd_sc_hd__decap_3
XFILLER_0_29_304 VGND VGND VPWR VPWR sky130_fd_sc_hd__decap_3
XFILLER_0_29_307 VGND VGND VPWR VPWR sky130_fd_sc_hd__decap_3
XFILLER_0_29_310 VGND VGND VPWR VPWR sky130_fd_sc_hd__decap_3
XFILLER_0_29_313 VGND VGND VPWR VPWR sky130_fd_sc_hd__decap_3
XFILLER_0_29_316 VGND VGND VPWR VPWR sky130_fd_sc_hd__fill_1
XFILLER_0_30_3 VGND VGND VPWR VPWR sky130_fd_sc_hd__decap_3
XFILLER_0_30_6 VGND VGND VPWR VPWR sky130_fd_sc_hd__decap_3
XFILLER_0_30_9 VGND VGND VPWR VPWR sky130_fd_sc_hd__decap_3
XFILLER_0_30_35 VGND VGND VPWR VPWR sky130_fd_sc_hd__fill_2
XFILLER_0_30_69 VGND VGND VPWR VPWR sky130_fd_sc_hd__decap_3
XFILLER_0_30_72 VGND VGND VPWR VPWR sky130_fd_sc_hd__decap_3
XFILLER_0_30_75 VGND VGND VPWR VPWR sky130_fd_sc_hd__decap_3
XFILLER_0_30_78 VGND VGND VPWR VPWR sky130_fd_sc_hd__decap_3
XFILLER_0_30_81 VGND VGND VPWR VPWR sky130_fd_sc_hd__decap_3
XFILLER_0_30_85 VGND VGND VPWR VPWR sky130_fd_sc_hd__decap_3
XFILLER_0_30_88 VGND VGND VPWR VPWR sky130_fd_sc_hd__decap_3
XFILLER_0_30_91 VGND VGND VPWR VPWR sky130_fd_sc_hd__decap_3
XFILLER_0_30_94 VGND VGND VPWR VPWR sky130_fd_sc_hd__decap_3
XFILLER_0_30_97 VGND VGND VPWR VPWR sky130_fd_sc_hd__decap_3
XFILLER_0_30_128 VGND VGND VPWR VPWR sky130_fd_sc_hd__decap_3
XFILLER_0_30_131 VGND VGND VPWR VPWR sky130_fd_sc_hd__fill_2
XFILLER_0_30_138 VGND VGND VPWR VPWR sky130_fd_sc_hd__fill_2
XFILLER_0_30_141 VGND VGND VPWR VPWR sky130_fd_sc_hd__fill_2
XFILLER_0_30_191 VGND VGND VPWR VPWR sky130_fd_sc_hd__decap_3
XFILLER_0_30_194 VGND VGND VPWR VPWR sky130_fd_sc_hd__fill_2
XFILLER_0_30_197 VGND VGND VPWR VPWR sky130_fd_sc_hd__decap_3
XFILLER_0_30_200 VGND VGND VPWR VPWR sky130_fd_sc_hd__decap_3
XFILLER_0_30_278 VGND VGND VPWR VPWR sky130_fd_sc_hd__decap_3
XFILLER_0_30_281 VGND VGND VPWR VPWR sky130_fd_sc_hd__decap_3
XFILLER_0_30_284 VGND VGND VPWR VPWR sky130_fd_sc_hd__decap_3
XFILLER_0_30_287 VGND VGND VPWR VPWR sky130_fd_sc_hd__decap_3
XFILLER_0_30_290 VGND VGND VPWR VPWR sky130_fd_sc_hd__decap_3
XFILLER_0_30_293 VGND VGND VPWR VPWR sky130_fd_sc_hd__decap_3
XFILLER_0_30_296 VGND VGND VPWR VPWR sky130_fd_sc_hd__decap_3
XFILLER_0_30_299 VGND VGND VPWR VPWR sky130_fd_sc_hd__decap_3
XFILLER_0_30_302 VGND VGND VPWR VPWR sky130_fd_sc_hd__decap_3
XFILLER_0_30_305 VGND VGND VPWR VPWR sky130_fd_sc_hd__decap_3
XFILLER_0_30_309 VGND VGND VPWR VPWR sky130_fd_sc_hd__decap_3
XFILLER_0_30_312 VGND VGND VPWR VPWR sky130_fd_sc_hd__decap_3
XFILLER_0_30_315 VGND VGND VPWR VPWR sky130_fd_sc_hd__fill_2
XFILLER_0_31_3 VGND VGND VPWR VPWR sky130_fd_sc_hd__decap_3
XFILLER_0_31_6 VGND VGND VPWR VPWR sky130_fd_sc_hd__fill_2
XFILLER_0_31_57 VGND VGND VPWR VPWR sky130_fd_sc_hd__decap_3
XFILLER_0_31_60 VGND VGND VPWR VPWR sky130_fd_sc_hd__fill_2
XFILLER_0_31_84 VGND VGND VPWR VPWR sky130_fd_sc_hd__fill_2
XFILLER_0_31_88 VGND VGND VPWR VPWR sky130_fd_sc_hd__decap_3
XFILLER_0_31_91 VGND VGND VPWR VPWR sky130_fd_sc_hd__fill_1
XFILLER_0_31_113 VGND VGND VPWR VPWR sky130_fd_sc_hd__fill_1
XFILLER_0_31_135 VGND VGND VPWR VPWR sky130_fd_sc_hd__decap_3
XFILLER_0_31_138 VGND VGND VPWR VPWR sky130_fd_sc_hd__fill_1
XFILLER_0_31_187 VGND VGND VPWR VPWR sky130_fd_sc_hd__decap_3
XFILLER_0_31_190 VGND VGND VPWR VPWR sky130_fd_sc_hd__decap_3
XFILLER_0_31_193 VGND VGND VPWR VPWR sky130_fd_sc_hd__decap_3
XFILLER_0_31_219 VGND VGND VPWR VPWR sky130_fd_sc_hd__fill_1
XFILLER_0_31_274 VGND VGND VPWR VPWR sky130_fd_sc_hd__decap_3
XFILLER_0_31_277 VGND VGND VPWR VPWR sky130_fd_sc_hd__decap_3
XFILLER_0_31_302 VGND VGND VPWR VPWR sky130_fd_sc_hd__decap_3
XFILLER_0_31_305 VGND VGND VPWR VPWR sky130_fd_sc_hd__decap_3
XFILLER_0_31_308 VGND VGND VPWR VPWR sky130_fd_sc_hd__decap_3
XFILLER_0_31_311 VGND VGND VPWR VPWR sky130_fd_sc_hd__decap_3
XFILLER_0_31_314 VGND VGND VPWR VPWR sky130_fd_sc_hd__decap_3
XFILLER_0_32_3 VGND VGND VPWR VPWR sky130_fd_sc_hd__decap_3
XFILLER_0_32_6 VGND VGND VPWR VPWR sky130_fd_sc_hd__decap_3
XFILLER_0_32_9 VGND VGND VPWR VPWR sky130_fd_sc_hd__decap_3
XFILLER_0_32_12 VGND VGND VPWR VPWR sky130_fd_sc_hd__decap_3
XFILLER_0_32_15 VGND VGND VPWR VPWR sky130_fd_sc_hd__decap_3
XFILLER_0_32_18 VGND VGND VPWR VPWR sky130_fd_sc_hd__decap_3
XFILLER_0_32_21 VGND VGND VPWR VPWR sky130_fd_sc_hd__decap_3
XFILLER_0_32_24 VGND VGND VPWR VPWR sky130_fd_sc_hd__decap_3
XFILLER_0_32_27 VGND VGND VPWR VPWR sky130_fd_sc_hd__fill_1
XFILLER_0_32_29 VGND VGND VPWR VPWR sky130_fd_sc_hd__fill_1
XFILLER_0_32_62 VGND VGND VPWR VPWR sky130_fd_sc_hd__fill_2
XFILLER_0_32_108 VGND VGND VPWR VPWR sky130_fd_sc_hd__decap_3
XFILLER_0_32_141 VGND VGND VPWR VPWR sky130_fd_sc_hd__fill_2
XFILLER_0_32_192 VGND VGND VPWR VPWR sky130_fd_sc_hd__decap_3
XFILLER_0_32_195 VGND VGND VPWR VPWR sky130_fd_sc_hd__fill_1
XFILLER_0_32_297 VGND VGND VPWR VPWR sky130_fd_sc_hd__decap_3
XFILLER_0_32_300 VGND VGND VPWR VPWR sky130_fd_sc_hd__decap_3
XFILLER_0_32_303 VGND VGND VPWR VPWR sky130_fd_sc_hd__decap_3
XFILLER_0_32_306 VGND VGND VPWR VPWR sky130_fd_sc_hd__fill_2
XFILLER_0_32_309 VGND VGND VPWR VPWR sky130_fd_sc_hd__decap_3
XFILLER_0_32_312 VGND VGND VPWR VPWR sky130_fd_sc_hd__decap_3
XFILLER_0_32_315 VGND VGND VPWR VPWR sky130_fd_sc_hd__fill_2
XFILLER_0_33_3 VGND VGND VPWR VPWR sky130_fd_sc_hd__decap_3
XFILLER_0_33_6 VGND VGND VPWR VPWR sky130_fd_sc_hd__decap_3
XFILLER_0_33_9 VGND VGND VPWR VPWR sky130_fd_sc_hd__decap_3
XFILLER_0_33_12 VGND VGND VPWR VPWR sky130_fd_sc_hd__decap_3
XFILLER_0_33_15 VGND VGND VPWR VPWR sky130_fd_sc_hd__decap_3
XFILLER_0_33_18 VGND VGND VPWR VPWR sky130_fd_sc_hd__decap_3
XFILLER_0_33_21 VGND VGND VPWR VPWR sky130_fd_sc_hd__decap_3
XFILLER_0_33_24 VGND VGND VPWR VPWR sky130_fd_sc_hd__decap_3
XFILLER_0_33_27 VGND VGND VPWR VPWR sky130_fd_sc_hd__fill_1
XFILLER_0_33_29 VGND VGND VPWR VPWR sky130_fd_sc_hd__decap_3
XFILLER_0_33_32 VGND VGND VPWR VPWR sky130_fd_sc_hd__decap_3
XFILLER_0_33_35 VGND VGND VPWR VPWR sky130_fd_sc_hd__decap_3
XFILLER_0_33_38 VGND VGND VPWR VPWR sky130_fd_sc_hd__fill_2
XFILLER_0_33_57 VGND VGND VPWR VPWR sky130_fd_sc_hd__decap_3
XFILLER_0_33_60 VGND VGND VPWR VPWR sky130_fd_sc_hd__decap_3
XFILLER_0_33_63 VGND VGND VPWR VPWR sky130_fd_sc_hd__decap_3
XFILLER_0_33_66 VGND VGND VPWR VPWR sky130_fd_sc_hd__fill_1
XFILLER_0_33_70 VGND VGND VPWR VPWR sky130_fd_sc_hd__decap_3
XFILLER_0_33_73 VGND VGND VPWR VPWR sky130_fd_sc_hd__decap_3
XFILLER_0_33_76 VGND VGND VPWR VPWR sky130_fd_sc_hd__fill_1
XFILLER_0_33_80 VGND VGND VPWR VPWR sky130_fd_sc_hd__fill_2
XFILLER_0_33_85 VGND VGND VPWR VPWR sky130_fd_sc_hd__fill_2
XFILLER_0_33_107 VGND VGND VPWR VPWR sky130_fd_sc_hd__decap_3
XFILLER_0_33_113 VGND VGND VPWR VPWR sky130_fd_sc_hd__fill_1
XFILLER_0_33_119 VGND VGND VPWR VPWR sky130_fd_sc_hd__fill_2
XFILLER_0_33_134 VGND VGND VPWR VPWR sky130_fd_sc_hd__fill_2
XFILLER_0_33_138 VGND VGND VPWR VPWR sky130_fd_sc_hd__fill_2
XFILLER_0_33_141 VGND VGND VPWR VPWR sky130_fd_sc_hd__fill_2
XFILLER_0_33_145 VGND VGND VPWR VPWR sky130_fd_sc_hd__decap_3
XFILLER_0_33_148 VGND VGND VPWR VPWR sky130_fd_sc_hd__decap_3
XFILLER_0_33_151 VGND VGND VPWR VPWR sky130_fd_sc_hd__fill_2
XFILLER_0_33_158 VGND VGND VPWR VPWR sky130_fd_sc_hd__fill_2
XFILLER_0_33_167 VGND VGND VPWR VPWR sky130_fd_sc_hd__fill_1
XFILLER_0_33_185 VGND VGND VPWR VPWR sky130_fd_sc_hd__fill_2
XFILLER_0_33_189 VGND VGND VPWR VPWR sky130_fd_sc_hd__decap_3
XFILLER_0_33_192 VGND VGND VPWR VPWR sky130_fd_sc_hd__decap_3
XFILLER_0_33_195 VGND VGND VPWR VPWR sky130_fd_sc_hd__fill_1
XFILLER_0_33_197 VGND VGND VPWR VPWR sky130_fd_sc_hd__decap_3
XFILLER_0_33_200 VGND VGND VPWR VPWR sky130_fd_sc_hd__decap_3
XFILLER_0_33_203 VGND VGND VPWR VPWR sky130_fd_sc_hd__decap_3
XFILLER_0_33_206 VGND VGND VPWR VPWR sky130_fd_sc_hd__decap_3
XFILLER_0_33_209 VGND VGND VPWR VPWR sky130_fd_sc_hd__decap_3
XFILLER_0_33_212 VGND VGND VPWR VPWR sky130_fd_sc_hd__decap_3
XFILLER_0_33_215 VGND VGND VPWR VPWR sky130_fd_sc_hd__decap_3
XFILLER_0_33_218 VGND VGND VPWR VPWR sky130_fd_sc_hd__decap_3
XFILLER_0_33_221 VGND VGND VPWR VPWR sky130_fd_sc_hd__decap_3
XFILLER_0_33_228 VGND VGND VPWR VPWR sky130_fd_sc_hd__decap_3
XFILLER_0_33_231 VGND VGND VPWR VPWR sky130_fd_sc_hd__decap_3
XFILLER_0_33_240 VGND VGND VPWR VPWR sky130_fd_sc_hd__fill_1
XFILLER_0_33_251 VGND VGND VPWR VPWR sky130_fd_sc_hd__fill_1
XFILLER_0_33_259 VGND VGND VPWR VPWR sky130_fd_sc_hd__decap_3
XFILLER_0_33_262 VGND VGND VPWR VPWR sky130_fd_sc_hd__decap_3
XFILLER_0_33_265 VGND VGND VPWR VPWR sky130_fd_sc_hd__decap_3
XFILLER_0_33_268 VGND VGND VPWR VPWR sky130_fd_sc_hd__decap_3
XFILLER_0_33_271 VGND VGND VPWR VPWR sky130_fd_sc_hd__decap_3
XFILLER_0_33_274 VGND VGND VPWR VPWR sky130_fd_sc_hd__decap_3
XFILLER_0_33_277 VGND VGND VPWR VPWR sky130_fd_sc_hd__decap_3
XFILLER_0_33_281 VGND VGND VPWR VPWR sky130_fd_sc_hd__decap_3
XFILLER_0_33_284 VGND VGND VPWR VPWR sky130_fd_sc_hd__decap_3
XFILLER_0_33_287 VGND VGND VPWR VPWR sky130_fd_sc_hd__decap_3
XFILLER_0_33_290 VGND VGND VPWR VPWR sky130_fd_sc_hd__decap_3
XFILLER_0_33_293 VGND VGND VPWR VPWR sky130_fd_sc_hd__decap_3
XFILLER_0_33_296 VGND VGND VPWR VPWR sky130_fd_sc_hd__decap_3
XFILLER_0_33_299 VGND VGND VPWR VPWR sky130_fd_sc_hd__decap_3
XFILLER_0_33_302 VGND VGND VPWR VPWR sky130_fd_sc_hd__decap_3
XFILLER_0_33_305 VGND VGND VPWR VPWR sky130_fd_sc_hd__decap_3
XFILLER_0_33_309 VGND VGND VPWR VPWR sky130_fd_sc_hd__decap_3
XFILLER_0_33_312 VGND VGND VPWR VPWR sky130_fd_sc_hd__decap_3
XFILLER_0_33_315 VGND VGND VPWR VPWR sky130_fd_sc_hd__fill_2
.ends
** sch_path: /mnt/c/Users/eleva/Documents/ChatGPT/Tiny Tapeout/tt-sky26e-ccro-adc/review/xschem/tt_um_eleva_ccro_adc.sch
.subckt tt_um_eleva_ccro_adc VDPWR VGND clk ena rst_n ui_in[0] ui_in[1] ui_in[2] ui_in[3] ui_in[4]
+ ui_in[5] ui_in[6] ui_in[7] uo_out[0] uo_out[1] uo_out[2] uo_out[3] uo_out[4] uo_out[5] uo_out[6] uo_out[7]
+ uio_in[0] uio_in[1] uio_in[2] uio_in[3] uio_in[4] uio_in[5] uio_in[6] uio_in[7] uio_out[0] uio_out[1]
+ uio_out[2] uio_out[3] uio_out[4] uio_out[5] uio_out[6] uio_out[7] uio_oe[0] uio_oe[1] uio_oe[2] uio_oe[3]
+ uio_oe[4] uio_oe[5] uio_oe[6] uio_oe[7] ua[0] ua[1] ua[2] ua[3] ua[4] ua[5] ua[6] ua[7]
*.PININFO VDPWR:B VGND:B clk:B ena:B rst_n:B ui_in[0]:B ui_in[1]:B ui_in[2]:B ui_in[3]:B ui_in[4]:B
*+ ui_in[5]:B ui_in[6]:B ui_in[7]:B uo_out[0]:B uo_out[1]:B uo_out[2]:B uo_out[3]:B uo_out[4]:B uo_out[5]:B
*+ uo_out[6]:B uo_out[7]:B uio_in[0]:B uio_in[1]:B uio_in[2]:B uio_in[3]:B uio_in[4]:B uio_in[5]:B uio_in[6]:B
*+ uio_in[7]:B uio_out[0]:B uio_out[1]:B uio_out[2]:B uio_out[3]:B uio_out[4]:B uio_out[5]:B uio_out[6]:B
*+ uio_out[7]:B uio_oe[0]:B uio_oe[1]:B uio_oe[2]:B uio_oe[3]:B uio_oe[4]:B uio_oe[5]:B uio_oe[6]:B uio_oe[7]:B
*+ ua[0]:B ua[1]:B ua[2]:B ua[3]:B ua[4]:B ua[5]:B ua[6]:B ua[7]:B
Xana ua[0] ua[1] ui_in[3] ui_in[4] VDPWR VGND p0 p1 p2 p3 p4 p5 p6 p7 p8 p9 p10 p11 p12 p13 p14 n0
+ n1 n2 n3 n4 n5 n6 n7 n8 n9 n10 n11 n12 n13 n14 adc_analog
Xdig VGND VDPWR clk uio_out[1] ui_in[1] ui_in[2] uo_out[0] uo_out[1] uo_out[2] uo_out[3] uo_out[4]
+ uo_out[5] uo_out[6] uo_out[7] ui_in[5] ui_in[0] rst_n uio_out[2] uio_out[0] n0 n10 n11 n12 n13 n14 n1 n2 n3
+ n4 n5 n6 n7 n8 n9 p0 p10 p11 p12 p13 p14 p1 p2 p3 p4 p5 p6 p7 p8 p9 uio_out[3] adc_readout
Xconst0 VGND VGND VDPWR VDPWR uio_oe[0] uio_out[4] sky130_fd_sc_hd__conb_1
Xconst1 VGND VGND VDPWR VDPWR uio_oe[1] uio_out[5] sky130_fd_sc_hd__conb_1
Xconst2 VGND VGND VDPWR VDPWR uio_oe[2] uio_out[6] sky130_fd_sc_hd__conb_1
Xconst3 VGND VGND VDPWR VDPWR uio_oe[3] uio_out[7] sky130_fd_sc_hd__conb_1
Xconst4 VGND VGND VDPWR VDPWR unused_hi4 uio_oe[4] sky130_fd_sc_hd__conb_1
Xconst5 VGND VGND VDPWR VDPWR unused_hi5 uio_oe[5] sky130_fd_sc_hd__conb_1
Xconst6 VGND VGND VDPWR VDPWR unused_hi6 uio_oe[6] sky130_fd_sc_hd__conb_1
Xconst7 VGND VGND VDPWR VDPWR unused_hi7 uio_oe[7] sky130_fd_sc_hd__conb_1
XDprotect_b0 VGND ui_in[3] sky130_fd_pr__diode_pw2nd_05v5 area=4.347e+11 perim=2.64e+06
XDprotect_b1 VGND ui_in[4] sky130_fd_pr__diode_pw2nd_05v5 area=4.347e+11 perim=2.64e+06
.ends

* expanding   symbol:  adc_analog.sym # of pins=36
** sym_path: /mnt/c/Users/eleva/Documents/ChatGPT/Tiny Tapeout/tt-sky26e-ccro-adc/review/xschem/adc_analog.sym
** sch_path: /mnt/c/Users/eleva/Documents/ChatGPT/Tiny Tapeout/tt-sky26e-ccro-adc/review/xschem/adc_analog.sch
.subckt adc_analog vinp vinn b0 b1 v g p0 p1 p2 p3 p4 p5 p6 p7 p8 p9 p10 p11 p12 p13 p14 n0 n1 n2 n3
+ n4 n5 n6 n7 n8 n9 n10 n11 n12 n13 n14
*.PININFO vinp:B vinn:B b0:B b1:B v:B g:B p0:B p1:B p2:B p3:B p4:B p5:B p6:B p7:B p8:B p9:B p10:B
*+ p11:B p12:B p13:B p14:B n0:B n1:B n2:B n3:B n4:B n5:B n6:B n7:B n8:B n9:B n10:B n11:B n12:B n13:B n14:B
Xf vinp vinn b0 b1 rp rn v g front
Xd rp rn v g p0 p1 p2 p3 p4 p5 p6 p7 p8 p9 p10 p11 p12 p13 p14 n0 n1 n2 n3 n4 n5 n6 n7 n8 n9 n10 n11
+ n12 n13 n14 dual
.ends

* expanding   symbol:  front.sym # of pins=8
** sym_path: /mnt/c/Users/eleva/Documents/ChatGPT/Tiny Tapeout/tt-sky26e-ccro-adc/review/xschem/front.sym
** sch_path: /mnt/c/Users/eleva/Documents/ChatGPT/Tiny Tapeout/tt-sky26e-ccro-adc/review/xschem/front.sch
.subckt front vinp vinn b0 b1 rp rn v g
*.PININFO vinp:B vinn:B b0:B b1:B rp:B rn:B v:B g:B
Xbias b0 b1 vb g4 g15 g20 v g bias
Xtailp sp vb g4 g15 g20 v tail
Xtailn sn vb g4 g15 g20 v tail
XMinp0 rp vinn sp sp sky130_fd_pr__pfet_01v8_lvt L=1 W=6 nf=1 ad=expr('int((@nf + 1)/2) * @W / @nf * 0.29')
+ as=expr('int((@nf + 2)/2) * @W / @nf * 0.29') pd=expr('2*int((@nf + 1)/2) * (@W / @nf + 0.29)') ps=expr('2*int((@nf + 2)/2) * (@W / @nf + 0.29)')
+ nrd=expr('0.29 / @W ') nrs=expr('0.29 / @W ') sa=0 sb=0 sd=0 mult=1 m=1
XMinp1 rp vinn sp sp sky130_fd_pr__pfet_01v8_lvt L=1 W=6 nf=1 ad=expr('int((@nf + 1)/2) * @W / @nf * 0.29')
+ as=expr('int((@nf + 2)/2) * @W / @nf * 0.29') pd=expr('2*int((@nf + 1)/2) * (@W / @nf + 0.29)') ps=expr('2*int((@nf + 2)/2) * (@W / @nf + 0.29)')
+ nrd=expr('0.29 / @W ') nrs=expr('0.29 / @W ') sa=0 sb=0 sd=0 mult=1 m=1
XMinp2 rp vinn sp sp sky130_fd_pr__pfet_01v8_lvt L=1 W=6 nf=1 ad=expr('int((@nf + 1)/2) * @W / @nf * 0.29')
+ as=expr('int((@nf + 2)/2) * @W / @nf * 0.29') pd=expr('2*int((@nf + 1)/2) * (@W / @nf + 0.29)') ps=expr('2*int((@nf + 2)/2) * (@W / @nf + 0.29)')
+ nrd=expr('0.29 / @W ') nrs=expr('0.29 / @W ') sa=0 sb=0 sd=0 mult=1 m=1
XMinp3 rp vinn sp sp sky130_fd_pr__pfet_01v8_lvt L=1 W=6 nf=1 ad=expr('int((@nf + 1)/2) * @W / @nf * 0.29')
+ as=expr('int((@nf + 2)/2) * @W / @nf * 0.29') pd=expr('2*int((@nf + 1)/2) * (@W / @nf + 0.29)') ps=expr('2*int((@nf + 2)/2) * (@W / @nf + 0.29)')
+ nrd=expr('0.29 / @W ') nrs=expr('0.29 / @W ') sa=0 sb=0 sd=0 mult=1 m=1
XMinn0 rn vinp sn sn sky130_fd_pr__pfet_01v8_lvt L=1 W=6 nf=1 ad=expr('int((@nf + 1)/2) * @W / @nf * 0.29')
+ as=expr('int((@nf + 2)/2) * @W / @nf * 0.29') pd=expr('2*int((@nf + 1)/2) * (@W / @nf + 0.29)') ps=expr('2*int((@nf + 2)/2) * (@W / @nf + 0.29)')
+ nrd=expr('0.29 / @W ') nrs=expr('0.29 / @W ') sa=0 sb=0 sd=0 mult=1 m=1
XMinn1 rn vinp sn sn sky130_fd_pr__pfet_01v8_lvt L=1 W=6 nf=1 ad=expr('int((@nf + 1)/2) * @W / @nf * 0.29')
+ as=expr('int((@nf + 2)/2) * @W / @nf * 0.29') pd=expr('2*int((@nf + 1)/2) * (@W / @nf + 0.29)') ps=expr('2*int((@nf + 2)/2) * (@W / @nf + 0.29)')
+ nrd=expr('0.29 / @W ') nrs=expr('0.29 / @W ') sa=0 sb=0 sd=0 mult=1 m=1
XMinn2 rn vinp sn sn sky130_fd_pr__pfet_01v8_lvt L=1 W=6 nf=1 ad=expr('int((@nf + 1)/2) * @W / @nf * 0.29')
+ as=expr('int((@nf + 2)/2) * @W / @nf * 0.29') pd=expr('2*int((@nf + 1)/2) * (@W / @nf + 0.29)') ps=expr('2*int((@nf + 2)/2) * (@W / @nf + 0.29)')
+ nrd=expr('0.29 / @W ') nrs=expr('0.29 / @W ') sa=0 sb=0 sd=0 mult=1 m=1
XMinn3 rn vinp sn sn sky130_fd_pr__pfet_01v8_lvt L=1 W=6 nf=1 ad=expr('int((@nf + 1)/2) * @W / @nf * 0.29')
+ as=expr('int((@nf + 2)/2) * @W / @nf * 0.29') pd=expr('2*int((@nf + 1)/2) * (@W / @nf + 0.29)') ps=expr('2*int((@nf + 2)/2) * (@W / @nf + 0.29)')
+ nrd=expr('0.29 / @W ') nrs=expr('0.29 / @W ') sa=0 sb=0 sd=0 mult=1 m=1
XRr0 sp mid g sky130_fd_pr__res_high_po_0p69 L=80 mult=1 m=1
XRr1 mid sn g sky130_fd_pr__res_high_po_0p69 L=80 mult=1 m=1
XCcapP rp g sky130_fd_pr__cap_mim_m3_1 W=21.8 L=21.8 MF=1 m=1
XCcapN rn g sky130_fd_pr__cap_mim_m3_1 W=21.8 L=21.8 MF=1 m=1
.ends

* expanding   symbol:  dual.sym # of pins=34
** sym_path: /mnt/c/Users/eleva/Documents/ChatGPT/Tiny Tapeout/tt-sky26e-ccro-adc/review/xschem/dual.sym
** sch_path: /mnt/c/Users/eleva/Documents/ChatGPT/Tiny Tapeout/tt-sky26e-ccro-adc/review/xschem/dual.sch
.subckt dual rp rn v g p0 p1 p2 p3 p4 p5 p6 p7 p8 p9 p10 p11 p12 p13 p14 n0 n1 n2 n3 n4 n5 n6 n7 n8
+ n9 n10 n11 n12 n13 n14
*.PININFO rp:B rn:B v:B g:B p0:B p1:B p2:B p3:B p4:B p5:B p6:B p7:B p8:B p9:B p10:B p11:B p12:B
*+ p13:B p14:B n0:B n1:B n2:B n3:B n4:B n5:B n6:B n7:B n8:B n9:B n10:B n11:B n12:B n13:B n14:B
Xp rp v g p0 p1 p2 p3 p4 p5 p6 p7 p8 p9 p10 p11 p12 p13 p14 ring
Xn rn v g n0 n1 n2 n3 n4 n5 n6 n7 n8 n9 n10 n11 n12 n13 n14 ring
.ends

* expanding   symbol:  bias.sym # of pins=8
** sym_path: /mnt/c/Users/eleva/Documents/ChatGPT/Tiny Tapeout/tt-sky26e-ccro-adc/review/xschem/bias.sym
** sch_path: /mnt/c/Users/eleva/Documents/ChatGPT/Tiny Tapeout/tt-sky26e-ccro-adc/review/xschem/bias.sch
.subckt bias b0 b1 vb g4 g15 g20 v g
*.PININFO b0:B b1:B vb:B g4:B g15:B g20:B v:B g:B
Xreference vb v g beta_ref
XMi0p nb0 b0 v v sky130_fd_pr__pfet_01v8 L=.15 W=.84 nf=1 ad=expr('int((@nf + 1)/2) * @W / @nf * 0.29')
+ as=expr('int((@nf + 2)/2) * @W / @nf * 0.29') pd=expr('2*int((@nf + 1)/2) * (@W / @nf + 0.29)') ps=expr('2*int((@nf + 2)/2) * (@W / @nf + 0.29)')
+ nrd=expr('0.29 / @W ') nrs=expr('0.29 / @W ') sa=0 sb=0 sd=0 mult=1 m=1
XMi0n nb0 b0 g g sky130_fd_pr__nfet_01v8 L=.15 W=.42 nf=1 ad=expr('int((@nf + 1)/2) * @W / @nf * 0.29')
+ as=expr('int((@nf + 2)/2) * @W / @nf * 0.29') pd=expr('2*int((@nf + 1)/2) * (@W / @nf + 0.29)') ps=expr('2*int((@nf + 2)/2) * (@W / @nf + 0.29)')
+ nrd=expr('0.29 / @W ') nrs=expr('0.29 / @W ') sa=0 sb=0 sd=0 mult=1 m=1
XMi1p nb1 b1 v v sky130_fd_pr__pfet_01v8 L=.15 W=.84 nf=1 ad=expr('int((@nf + 1)/2) * @W / @nf * 0.29')
+ as=expr('int((@nf + 2)/2) * @W / @nf * 0.29') pd=expr('2*int((@nf + 1)/2) * (@W / @nf + 0.29)') ps=expr('2*int((@nf + 2)/2) * (@W / @nf + 0.29)')
+ nrd=expr('0.29 / @W ') nrs=expr('0.29 / @W ') sa=0 sb=0 sd=0 mult=1 m=1
XMi1n nb1 b1 g g sky130_fd_pr__nfet_01v8 L=.15 W=.42 nf=1 ad=expr('int((@nf + 1)/2) * @W / @nf * 0.29')
+ as=expr('int((@nf + 2)/2) * @W / @nf * 0.29') pd=expr('2*int((@nf + 1)/2) * (@W / @nf + 0.29)') ps=expr('2*int((@nf + 2)/2) * (@W / @nf + 0.29)')
+ nrd=expr('0.29 / @W ') nrs=expr('0.29 / @W ') sa=0 sb=0 sd=0 mult=1 m=1
Xonlylow nb0 b1 off4 v g nor2
XMi4p en4 off4 v v sky130_fd_pr__pfet_01v8 L=.15 W=.84 nf=1 ad=expr('int((@nf + 1)/2) * @W / @nf * 0.29')
+ as=expr('int((@nf + 2)/2) * @W / @nf * 0.29') pd=expr('2*int((@nf + 1)/2) * (@W / @nf + 0.29)') ps=expr('2*int((@nf + 2)/2) * (@W / @nf + 0.29)')
+ nrd=expr('0.29 / @W ') nrs=expr('0.29 / @W ') sa=0 sb=0 sd=0 mult=1 m=1
XMi4n en4 off4 g g sky130_fd_pr__nfet_01v8 L=.15 W=.42 nf=1 ad=expr('int((@nf + 1)/2) * @W / @nf * 0.29')
+ as=expr('int((@nf + 2)/2) * @W / @nf * 0.29') pd=expr('2*int((@nf + 1)/2) * (@W / @nf + 0.29)') ps=expr('2*int((@nf + 2)/2) * (@W / @nf + 0.29)')
+ nrd=expr('0.29 / @W ') nrs=expr('0.29 / @W ') sa=0 sb=0 sd=0 mult=1 m=1
Xboth nb0 nb1 en20 v g nor2
Xzero b0 b1 zero v g nor2
Xdiff zero en20 off15 v g nor2
XMi15p en15 off15 v v sky130_fd_pr__pfet_01v8 L=.15 W=.84 nf=1 ad=expr('int((@nf + 1)/2) * @W / @nf * 0.29')
+ as=expr('int((@nf + 2)/2) * @W / @nf * 0.29') pd=expr('2*int((@nf + 1)/2) * (@W / @nf + 0.29)') ps=expr('2*int((@nf + 2)/2) * (@W / @nf + 0.29)')
+ nrd=expr('0.29 / @W ') nrs=expr('0.29 / @W ') sa=0 sb=0 sd=0 mult=1 m=1
XMi15n en15 off15 g g sky130_fd_pr__nfet_01v8 L=.15 W=.42 nf=1 ad=expr('int((@nf + 1)/2) * @W / @nf * 0.29')
+ as=expr('int((@nf + 2)/2) * @W / @nf * 0.29') pd=expr('2*int((@nf + 1)/2) * (@W / @nf + 0.29)') ps=expr('2*int((@nf + 2)/2) * (@W / @nf + 0.29)')
+ nrd=expr('0.29 / @W ') nrs=expr('0.29 / @W ') sa=0 sb=0 sd=0 mult=1 m=1
XMi20p off20 en20 v v sky130_fd_pr__pfet_01v8 L=.15 W=.84 nf=1 ad=expr('int((@nf + 1)/2) * @W / @nf * 0.29')
+ as=expr('int((@nf + 2)/2) * @W / @nf * 0.29') pd=expr('2*int((@nf + 1)/2) * (@W / @nf + 0.29)') ps=expr('2*int((@nf + 2)/2) * (@W / @nf + 0.29)')
+ nrd=expr('0.29 / @W ') nrs=expr('0.29 / @W ') sa=0 sb=0 sd=0 mult=1 m=1
XMi20n off20 en20 g g sky130_fd_pr__nfet_01v8 L=.15 W=.42 nf=1 ad=expr('int((@nf + 1)/2) * @W / @nf * 0.29')
+ as=expr('int((@nf + 2)/2) * @W / @nf * 0.29') pd=expr('2*int((@nf + 1)/2) * (@W / @nf + 0.29)') ps=expr('2*int((@nf + 2)/2) * (@W / @nf + 0.29)')
+ nrd=expr('0.29 / @W ') nrs=expr('0.29 / @W ') sa=0 sb=0 sd=0 mult=1 m=1
Xsw4 en4 off4 vb g4 v g tailgate
Xsw15 en15 off15 vb g15 v g tailgate
Xsw20 en20 off20 vb g20 v g tailgate
.ends

* expanding   symbol:  tail.sym # of pins=6
** sym_path: /mnt/c/Users/eleva/Documents/ChatGPT/Tiny Tapeout/tt-sky26e-ccro-adc/review/xschem/tail.sym
** sch_path: /mnt/c/Users/eleva/Documents/ChatGPT/Tiny Tapeout/tt-sky26e-ccro-adc/review/xschem/tail.sch
.subckt tail s vb g4 g15 g20 v
*.PININFO s:B vb:B g4:B g15:B g20:B v:B
XMone s vb v v sky130_fd_pr__pfet_01v8 L=2 W=1 nf=1 ad=expr('int((@nf + 1)/2) * @W / @nf * 0.29') as=expr('int((@nf + 2)/2) * @W / @nf * 0.29')
+ pd=expr('2*int((@nf + 1)/2) * (@W / @nf + 0.29)') ps=expr('2*int((@nf + 2)/2) * (@W / @nf + 0.29)') nrd=expr('0.29 / @W ')
+ nrs=expr('0.29 / @W ') sa=0 sb=0 sd=0 mult=1 m=1
Xunits4 s g4 v units4
Xunits15 s g15 v units15
Xunits20 s g20 v units20
.ends

* expanding   symbol:  ring.sym # of pins=18
** sym_path: /mnt/c/Users/eleva/Documents/ChatGPT/Tiny Tapeout/tt-sky26e-ccro-adc/review/xschem/ring.sym
** sch_path: /mnt/c/Users/eleva/Documents/ChatGPT/Tiny Tapeout/tt-sky26e-ccro-adc/review/xschem/ring.sch
.subckt ring rail v g t0 t1 t2 t3 t4 t5 t6 t7 t8 t9 t10 t11 t12 t13 t14
*.PININFO rail:B v:B g:B t0:B t1:B t2:B t3:B t4:B t5:B t6:B t7:B t8:B t9:B t10:B t11:B t12:B t13:B
*+ t14:B
Xbank rail v g oa0 ob0 oa1 ob1 oa2 ob2 oa3 ob3 oa4 ob4 oa5 ob5 oa6 ob6 oa7 ob7 oa8 ob8 oa9 ob9 oa10
+ ob10 oa11 ob11 oa12 ob12 oa13 ob13 oa14 ob14 bank
Xl0 oa0 ob0 t0 v g cvsl
Xl1 oa1 ob1 t1 v g cvsl
Xl2 oa2 ob2 t2 v g cvsl
Xl3 oa3 ob3 t3 v g cvsl
Xl4 oa4 ob4 t4 v g cvsl
Xl5 oa5 ob5 t5 v g cvsl
Xl6 oa6 ob6 t6 v g cvsl
Xl7 oa7 ob7 t7 v g cvsl
Xl8 oa8 ob8 t8 v g cvsl
Xl9 oa9 ob9 t9 v g cvsl
Xl10 oa10 ob10 t10 v g cvsl
Xl11 oa11 ob11 t11 v g cvsl
Xl12 oa12 ob12 t12 v g cvsl
Xl13 oa13 ob13 t13 v g cvsl
Xl14 oa14 ob14 t14 v g cvsl
.ends

* expanding   symbol:  beta_ref.sym # of pins=3
** sym_path: /mnt/c/Users/eleva/Documents/ChatGPT/Tiny Tapeout/tt-sky26e-ccro-adc/review/xschem/beta_ref.sym
** sch_path: /mnt/c/Users/eleva/Documents/ChatGPT/Tiny Tapeout/tt-sky26e-ccro-adc/review/xschem/beta_ref.sch
.subckt beta_ref vb v g
*.PININFO vb:B v:B g:B
XMp0 vb vb v v sky130_fd_pr__pfet_01v8 L=2 W=2 nf=1 ad=expr('int((@nf + 1)/2) * @W / @nf * 0.29') as=expr('int((@nf + 2)/2) * @W / @nf * 0.29')
+ pd=expr('2*int((@nf + 1)/2) * (@W / @nf + 0.29)') ps=expr('2*int((@nf + 2)/2) * (@W / @nf + 0.29)') nrd=expr('0.29 / @W ')
+ nrs=expr('0.29 / @W ') sa=0 sb=0 sd=0 mult=1 m=1
XMn0 vn vn g g sky130_fd_pr__nfet_01v8 L=2 W=2 nf=1 ad=expr('int((@nf + 1)/2) * @W / @nf * 0.29') as=expr('int((@nf + 2)/2) * @W / @nf * 0.29')
+ pd=expr('2*int((@nf + 1)/2) * (@W / @nf + 0.29)') ps=expr('2*int((@nf + 2)/2) * (@W / @nf + 0.29)') nrd=expr('0.29 / @W ')
+ nrs=expr('0.29 / @W ') sa=0 sb=0 sd=0 mult=1 m=1
XMp1 vn vb v v sky130_fd_pr__pfet_01v8 L=2 W=2 nf=1 ad=expr('int((@nf + 1)/2) * @W / @nf * 0.29') as=expr('int((@nf + 2)/2) * @W / @nf * 0.29')
+ pd=expr('2*int((@nf + 1)/2) * (@W / @nf + 0.29)') ps=expr('2*int((@nf + 2)/2) * (@W / @nf + 0.29)') nrd=expr('0.29 / @W ')
+ nrs=expr('0.29 / @W ') sa=0 sb=0 sd=0 mult=1 m=1
XMn1 vb vn rs g sky130_fd_pr__nfet_01v8 L=2 W=8 nf=1 ad=expr('int((@nf + 1)/2) * @W / @nf * 0.29') as=expr('int((@nf + 2)/2) * @W / @nf * 0.29')
+ pd=expr('2*int((@nf + 1)/2) * (@W / @nf + 0.29)') ps=expr('2*int((@nf + 2)/2) * (@W / @nf + 0.29)') nrd=expr('0.29 / @W ')
+ nrs=expr('0.29 / @W ') sa=0 sb=0 sd=0 mult=1 m=1
XRref0 rs refmid g sky130_fd_pr__res_high_po_0p69 L=97.1 mult=1 m=1
XRref1 refmid g g sky130_fd_pr__res_high_po_0p69 L=97.1 mult=1 m=1
XMweak kick g v v sky130_fd_pr__pfet_01v8 L=12 W=.42 nf=1 ad=expr('int((@nf + 1)/2) * @W / @nf * 0.29')
+ as=expr('int((@nf + 2)/2) * @W / @nf * 0.29') pd=expr('2*int((@nf + 1)/2) * (@W / @nf + 0.29)') ps=expr('2*int((@nf + 2)/2) * (@W / @nf + 0.29)')
+ nrd=expr('0.29 / @W ') nrs=expr('0.29 / @W ') sa=0 sb=0 sd=0 mult=1 m=1
XMsense kick vn g g sky130_fd_pr__nfet_01v8_lvt L=.15 W=5 nf=1 ad=expr('int((@nf + 1)/2) * @W / @nf * 0.29')
+ as=expr('int((@nf + 2)/2) * @W / @nf * 0.29') pd=expr('2*int((@nf + 1)/2) * (@W / @nf + 0.29)') ps=expr('2*int((@nf + 2)/2) * (@W / @nf + 0.29)')
+ nrd=expr('0.29 / @W ') nrs=expr('0.29 / @W ') sa=0 sb=0 sd=0 mult=1 m=1
XMkick vb kick g g sky130_fd_pr__nfet_01v8 L=1 W=.5 nf=1 ad=expr('int((@nf + 1)/2) * @W / @nf * 0.29')
+ as=expr('int((@nf + 2)/2) * @W / @nf * 0.29') pd=expr('2*int((@nf + 1)/2) * (@W / @nf + 0.29)') ps=expr('2*int((@nf + 2)/2) * (@W / @nf + 0.29)')
+ nrd=expr('0.29 / @W ') nrs=expr('0.29 / @W ') sa=0 sb=0 sd=0 mult=1 m=1
.ends

* expanding   symbol:  nor2.sym # of pins=5
** sym_path: /mnt/c/Users/eleva/Documents/ChatGPT/Tiny Tapeout/tt-sky26e-ccro-adc/review/xschem/nor2.sym
** sch_path: /mnt/c/Users/eleva/Documents/ChatGPT/Tiny Tapeout/tt-sky26e-ccro-adc/review/xschem/nor2.sch
.subckt nor2 a b y v g
*.PININFO a:B b:B y:B v:B g:B
XMp0 mid a v v sky130_fd_pr__pfet_01v8 L=.15 W=.84 nf=1 ad=expr('int((@nf + 1)/2) * @W / @nf * 0.29')
+ as=expr('int((@nf + 2)/2) * @W / @nf * 0.29') pd=expr('2*int((@nf + 1)/2) * (@W / @nf + 0.29)') ps=expr('2*int((@nf + 2)/2) * (@W / @nf + 0.29)')
+ nrd=expr('0.29 / @W ') nrs=expr('0.29 / @W ') sa=0 sb=0 sd=0 mult=1 m=1
XMp1 y b mid v sky130_fd_pr__pfet_01v8 L=.15 W=.84 nf=1 ad=expr('int((@nf + 1)/2) * @W / @nf * 0.29')
+ as=expr('int((@nf + 2)/2) * @W / @nf * 0.29') pd=expr('2*int((@nf + 1)/2) * (@W / @nf + 0.29)') ps=expr('2*int((@nf + 2)/2) * (@W / @nf + 0.29)')
+ nrd=expr('0.29 / @W ') nrs=expr('0.29 / @W ') sa=0 sb=0 sd=0 mult=1 m=1
XMn0 y a g g sky130_fd_pr__nfet_01v8 L=.15 W=.42 nf=1 ad=expr('int((@nf + 1)/2) * @W / @nf * 0.29') as=expr('int((@nf + 2)/2) * @W / @nf * 0.29')
+ pd=expr('2*int((@nf + 1)/2) * (@W / @nf + 0.29)') ps=expr('2*int((@nf + 2)/2) * (@W / @nf + 0.29)') nrd=expr('0.29 / @W ')
+ nrs=expr('0.29 / @W ') sa=0 sb=0 sd=0 mult=1 m=1
XMn1 y b g g sky130_fd_pr__nfet_01v8 L=.15 W=.42 nf=1 ad=expr('int((@nf + 1)/2) * @W / @nf * 0.29') as=expr('int((@nf + 2)/2) * @W / @nf * 0.29')
+ pd=expr('2*int((@nf + 1)/2) * (@W / @nf + 0.29)') ps=expr('2*int((@nf + 2)/2) * (@W / @nf + 0.29)') nrd=expr('0.29 / @W ')
+ nrs=expr('0.29 / @W ') sa=0 sb=0 sd=0 mult=1 m=1
.ends

* expanding   symbol:  tailgate.sym # of pins=6
** sym_path: /mnt/c/Users/eleva/Documents/ChatGPT/Tiny Tapeout/tt-sky26e-ccro-adc/review/xschem/tailgate.sym
** sch_path: /mnt/c/Users/eleva/Documents/ChatGPT/Tiny Tapeout/tt-sky26e-ccro-adc/review/xschem/tailgate.sch
.subckt tailgate en enb vb out v g
*.PININFO en:B enb:B vb:B out:B v:B g:B
XMonp out enb vb v sky130_fd_pr__pfet_01v8 L=.15 W=.84 nf=1 ad=expr('int((@nf + 1)/2) * @W / @nf * 0.29')
+ as=expr('int((@nf + 2)/2) * @W / @nf * 0.29') pd=expr('2*int((@nf + 1)/2) * (@W / @nf + 0.29)') ps=expr('2*int((@nf + 2)/2) * (@W / @nf + 0.29)')
+ nrd=expr('0.29 / @W ') nrs=expr('0.29 / @W ') sa=0 sb=0 sd=0 mult=1 m=1
XMonn out en vb g sky130_fd_pr__nfet_01v8 L=.15 W=.42 nf=1 ad=expr('int((@nf + 1)/2) * @W / @nf * 0.29')
+ as=expr('int((@nf + 2)/2) * @W / @nf * 0.29') pd=expr('2*int((@nf + 1)/2) * (@W / @nf + 0.29)') ps=expr('2*int((@nf + 2)/2) * (@W / @nf + 0.29)')
+ nrd=expr('0.29 / @W ') nrs=expr('0.29 / @W ') sa=0 sb=0 sd=0 mult=1 m=1
XMoff out en v v sky130_fd_pr__pfet_01v8 L=.15 W=.84 nf=1 ad=expr('int((@nf + 1)/2) * @W / @nf * 0.29')
+ as=expr('int((@nf + 2)/2) * @W / @nf * 0.29') pd=expr('2*int((@nf + 1)/2) * (@W / @nf + 0.29)') ps=expr('2*int((@nf + 2)/2) * (@W / @nf + 0.29)')
+ nrd=expr('0.29 / @W ') nrs=expr('0.29 / @W ') sa=0 sb=0 sd=0 mult=1 m=1
.ends

* expanding   symbol:  units4.sym # of pins=3
** sym_path: /mnt/c/Users/eleva/Documents/ChatGPT/Tiny Tapeout/tt-sky26e-ccro-adc/review/xschem/units4.sym
** sch_path: /mnt/c/Users/eleva/Documents/ChatGPT/Tiny Tapeout/tt-sky26e-ccro-adc/review/xschem/units4.sch
.subckt units4 s control v
*.PININFO s:B control:B v:B
XMg4_1 s control v v sky130_fd_pr__pfet_01v8 L=2 W=1 nf=1 ad=expr('int((@nf + 1)/2) * @W / @nf * 0.29')
+ as=expr('int((@nf + 2)/2) * @W / @nf * 0.29') pd=expr('2*int((@nf + 1)/2) * (@W / @nf + 0.29)') ps=expr('2*int((@nf + 2)/2) * (@W / @nf + 0.29)')
+ nrd=expr('0.29 / @W ') nrs=expr('0.29 / @W ') sa=0 sb=0 sd=0 mult=1 m=1
XMg4_2 s control v v sky130_fd_pr__pfet_01v8 L=2 W=1 nf=1 ad=expr('int((@nf + 1)/2) * @W / @nf * 0.29')
+ as=expr('int((@nf + 2)/2) * @W / @nf * 0.29') pd=expr('2*int((@nf + 1)/2) * (@W / @nf + 0.29)') ps=expr('2*int((@nf + 2)/2) * (@W / @nf + 0.29)')
+ nrd=expr('0.29 / @W ') nrs=expr('0.29 / @W ') sa=0 sb=0 sd=0 mult=1 m=1
XMg4_3 s control v v sky130_fd_pr__pfet_01v8 L=2 W=1 nf=1 ad=expr('int((@nf + 1)/2) * @W / @nf * 0.29')
+ as=expr('int((@nf + 2)/2) * @W / @nf * 0.29') pd=expr('2*int((@nf + 1)/2) * (@W / @nf + 0.29)') ps=expr('2*int((@nf + 2)/2) * (@W / @nf + 0.29)')
+ nrd=expr('0.29 / @W ') nrs=expr('0.29 / @W ') sa=0 sb=0 sd=0 mult=1 m=1
XMg4_4 s control v v sky130_fd_pr__pfet_01v8 L=2 W=1 nf=1 ad=expr('int((@nf + 1)/2) * @W / @nf * 0.29')
+ as=expr('int((@nf + 2)/2) * @W / @nf * 0.29') pd=expr('2*int((@nf + 1)/2) * (@W / @nf + 0.29)') ps=expr('2*int((@nf + 2)/2) * (@W / @nf + 0.29)')
+ nrd=expr('0.29 / @W ') nrs=expr('0.29 / @W ') sa=0 sb=0 sd=0 mult=1 m=1
.ends

* expanding   symbol:  units15.sym # of pins=3
** sym_path: /mnt/c/Users/eleva/Documents/ChatGPT/Tiny Tapeout/tt-sky26e-ccro-adc/review/xschem/units15.sym
** sch_path: /mnt/c/Users/eleva/Documents/ChatGPT/Tiny Tapeout/tt-sky26e-ccro-adc/review/xschem/units15.sch
.subckt units15 s control v
*.PININFO s:B control:B v:B
XMg15_1 s control v v sky130_fd_pr__pfet_01v8 L=2 W=1 nf=1 ad=expr('int((@nf + 1)/2) * @W / @nf * 0.29')
+ as=expr('int((@nf + 2)/2) * @W / @nf * 0.29') pd=expr('2*int((@nf + 1)/2) * (@W / @nf + 0.29)') ps=expr('2*int((@nf + 2)/2) * (@W / @nf + 0.29)')
+ nrd=expr('0.29 / @W ') nrs=expr('0.29 / @W ') sa=0 sb=0 sd=0 mult=1 m=1
XMg15_2 s control v v sky130_fd_pr__pfet_01v8 L=2 W=1 nf=1 ad=expr('int((@nf + 1)/2) * @W / @nf * 0.29')
+ as=expr('int((@nf + 2)/2) * @W / @nf * 0.29') pd=expr('2*int((@nf + 1)/2) * (@W / @nf + 0.29)') ps=expr('2*int((@nf + 2)/2) * (@W / @nf + 0.29)')
+ nrd=expr('0.29 / @W ') nrs=expr('0.29 / @W ') sa=0 sb=0 sd=0 mult=1 m=1
XMg15_3 s control v v sky130_fd_pr__pfet_01v8 L=2 W=1 nf=1 ad=expr('int((@nf + 1)/2) * @W / @nf * 0.29')
+ as=expr('int((@nf + 2)/2) * @W / @nf * 0.29') pd=expr('2*int((@nf + 1)/2) * (@W / @nf + 0.29)') ps=expr('2*int((@nf + 2)/2) * (@W / @nf + 0.29)')
+ nrd=expr('0.29 / @W ') nrs=expr('0.29 / @W ') sa=0 sb=0 sd=0 mult=1 m=1
XMg15_4 s control v v sky130_fd_pr__pfet_01v8 L=2 W=1 nf=1 ad=expr('int((@nf + 1)/2) * @W / @nf * 0.29')
+ as=expr('int((@nf + 2)/2) * @W / @nf * 0.29') pd=expr('2*int((@nf + 1)/2) * (@W / @nf + 0.29)') ps=expr('2*int((@nf + 2)/2) * (@W / @nf + 0.29)')
+ nrd=expr('0.29 / @W ') nrs=expr('0.29 / @W ') sa=0 sb=0 sd=0 mult=1 m=1
XMg15_5 s control v v sky130_fd_pr__pfet_01v8 L=2 W=1 nf=1 ad=expr('int((@nf + 1)/2) * @W / @nf * 0.29')
+ as=expr('int((@nf + 2)/2) * @W / @nf * 0.29') pd=expr('2*int((@nf + 1)/2) * (@W / @nf + 0.29)') ps=expr('2*int((@nf + 2)/2) * (@W / @nf + 0.29)')
+ nrd=expr('0.29 / @W ') nrs=expr('0.29 / @W ') sa=0 sb=0 sd=0 mult=1 m=1
XMg15_6 s control v v sky130_fd_pr__pfet_01v8 L=2 W=1 nf=1 ad=expr('int((@nf + 1)/2) * @W / @nf * 0.29')
+ as=expr('int((@nf + 2)/2) * @W / @nf * 0.29') pd=expr('2*int((@nf + 1)/2) * (@W / @nf + 0.29)') ps=expr('2*int((@nf + 2)/2) * (@W / @nf + 0.29)')
+ nrd=expr('0.29 / @W ') nrs=expr('0.29 / @W ') sa=0 sb=0 sd=0 mult=1 m=1
XMg15_7 s control v v sky130_fd_pr__pfet_01v8 L=2 W=1 nf=1 ad=expr('int((@nf + 1)/2) * @W / @nf * 0.29')
+ as=expr('int((@nf + 2)/2) * @W / @nf * 0.29') pd=expr('2*int((@nf + 1)/2) * (@W / @nf + 0.29)') ps=expr('2*int((@nf + 2)/2) * (@W / @nf + 0.29)')
+ nrd=expr('0.29 / @W ') nrs=expr('0.29 / @W ') sa=0 sb=0 sd=0 mult=1 m=1
XMg15_8 s control v v sky130_fd_pr__pfet_01v8 L=2 W=1 nf=1 ad=expr('int((@nf + 1)/2) * @W / @nf * 0.29')
+ as=expr('int((@nf + 2)/2) * @W / @nf * 0.29') pd=expr('2*int((@nf + 1)/2) * (@W / @nf + 0.29)') ps=expr('2*int((@nf + 2)/2) * (@W / @nf + 0.29)')
+ nrd=expr('0.29 / @W ') nrs=expr('0.29 / @W ') sa=0 sb=0 sd=0 mult=1 m=1
XMg15_9 s control v v sky130_fd_pr__pfet_01v8 L=2 W=1 nf=1 ad=expr('int((@nf + 1)/2) * @W / @nf * 0.29')
+ as=expr('int((@nf + 2)/2) * @W / @nf * 0.29') pd=expr('2*int((@nf + 1)/2) * (@W / @nf + 0.29)') ps=expr('2*int((@nf + 2)/2) * (@W / @nf + 0.29)')
+ nrd=expr('0.29 / @W ') nrs=expr('0.29 / @W ') sa=0 sb=0 sd=0 mult=1 m=1
XMg15_10 s control v v sky130_fd_pr__pfet_01v8 L=2 W=1 nf=1 ad=expr('int((@nf + 1)/2) * @W / @nf * 0.29')
+ as=expr('int((@nf + 2)/2) * @W / @nf * 0.29') pd=expr('2*int((@nf + 1)/2) * (@W / @nf + 0.29)') ps=expr('2*int((@nf + 2)/2) * (@W / @nf + 0.29)')
+ nrd=expr('0.29 / @W ') nrs=expr('0.29 / @W ') sa=0 sb=0 sd=0 mult=1 m=1
XMg15_11 s control v v sky130_fd_pr__pfet_01v8 L=2 W=1 nf=1 ad=expr('int((@nf + 1)/2) * @W / @nf * 0.29')
+ as=expr('int((@nf + 2)/2) * @W / @nf * 0.29') pd=expr('2*int((@nf + 1)/2) * (@W / @nf + 0.29)') ps=expr('2*int((@nf + 2)/2) * (@W / @nf + 0.29)')
+ nrd=expr('0.29 / @W ') nrs=expr('0.29 / @W ') sa=0 sb=0 sd=0 mult=1 m=1
XMg15_12 s control v v sky130_fd_pr__pfet_01v8 L=2 W=1 nf=1 ad=expr('int((@nf + 1)/2) * @W / @nf * 0.29')
+ as=expr('int((@nf + 2)/2) * @W / @nf * 0.29') pd=expr('2*int((@nf + 1)/2) * (@W / @nf + 0.29)') ps=expr('2*int((@nf + 2)/2) * (@W / @nf + 0.29)')
+ nrd=expr('0.29 / @W ') nrs=expr('0.29 / @W ') sa=0 sb=0 sd=0 mult=1 m=1
XMg15_13 s control v v sky130_fd_pr__pfet_01v8 L=2 W=1 nf=1 ad=expr('int((@nf + 1)/2) * @W / @nf * 0.29')
+ as=expr('int((@nf + 2)/2) * @W / @nf * 0.29') pd=expr('2*int((@nf + 1)/2) * (@W / @nf + 0.29)') ps=expr('2*int((@nf + 2)/2) * (@W / @nf + 0.29)')
+ nrd=expr('0.29 / @W ') nrs=expr('0.29 / @W ') sa=0 sb=0 sd=0 mult=1 m=1
XMg15_14 s control v v sky130_fd_pr__pfet_01v8 L=2 W=1 nf=1 ad=expr('int((@nf + 1)/2) * @W / @nf * 0.29')
+ as=expr('int((@nf + 2)/2) * @W / @nf * 0.29') pd=expr('2*int((@nf + 1)/2) * (@W / @nf + 0.29)') ps=expr('2*int((@nf + 2)/2) * (@W / @nf + 0.29)')
+ nrd=expr('0.29 / @W ') nrs=expr('0.29 / @W ') sa=0 sb=0 sd=0 mult=1 m=1
XMg15_15 s control v v sky130_fd_pr__pfet_01v8 L=2 W=1 nf=1 ad=expr('int((@nf + 1)/2) * @W / @nf * 0.29')
+ as=expr('int((@nf + 2)/2) * @W / @nf * 0.29') pd=expr('2*int((@nf + 1)/2) * (@W / @nf + 0.29)') ps=expr('2*int((@nf + 2)/2) * (@W / @nf + 0.29)')
+ nrd=expr('0.29 / @W ') nrs=expr('0.29 / @W ') sa=0 sb=0 sd=0 mult=1 m=1
.ends

* expanding   symbol:  units20.sym # of pins=3
** sym_path: /mnt/c/Users/eleva/Documents/ChatGPT/Tiny Tapeout/tt-sky26e-ccro-adc/review/xschem/units20.sym
** sch_path: /mnt/c/Users/eleva/Documents/ChatGPT/Tiny Tapeout/tt-sky26e-ccro-adc/review/xschem/units20.sch
.subckt units20 s control v
*.PININFO s:B control:B v:B
XMg20_1 s control v v sky130_fd_pr__pfet_01v8 L=2 W=1 nf=1 ad=expr('int((@nf + 1)/2) * @W / @nf * 0.29')
+ as=expr('int((@nf + 2)/2) * @W / @nf * 0.29') pd=expr('2*int((@nf + 1)/2) * (@W / @nf + 0.29)') ps=expr('2*int((@nf + 2)/2) * (@W / @nf + 0.29)')
+ nrd=expr('0.29 / @W ') nrs=expr('0.29 / @W ') sa=0 sb=0 sd=0 mult=1 m=1
XMg20_2 s control v v sky130_fd_pr__pfet_01v8 L=2 W=1 nf=1 ad=expr('int((@nf + 1)/2) * @W / @nf * 0.29')
+ as=expr('int((@nf + 2)/2) * @W / @nf * 0.29') pd=expr('2*int((@nf + 1)/2) * (@W / @nf + 0.29)') ps=expr('2*int((@nf + 2)/2) * (@W / @nf + 0.29)')
+ nrd=expr('0.29 / @W ') nrs=expr('0.29 / @W ') sa=0 sb=0 sd=0 mult=1 m=1
XMg20_3 s control v v sky130_fd_pr__pfet_01v8 L=2 W=1 nf=1 ad=expr('int((@nf + 1)/2) * @W / @nf * 0.29')
+ as=expr('int((@nf + 2)/2) * @W / @nf * 0.29') pd=expr('2*int((@nf + 1)/2) * (@W / @nf + 0.29)') ps=expr('2*int((@nf + 2)/2) * (@W / @nf + 0.29)')
+ nrd=expr('0.29 / @W ') nrs=expr('0.29 / @W ') sa=0 sb=0 sd=0 mult=1 m=1
XMg20_4 s control v v sky130_fd_pr__pfet_01v8 L=2 W=1 nf=1 ad=expr('int((@nf + 1)/2) * @W / @nf * 0.29')
+ as=expr('int((@nf + 2)/2) * @W / @nf * 0.29') pd=expr('2*int((@nf + 1)/2) * (@W / @nf + 0.29)') ps=expr('2*int((@nf + 2)/2) * (@W / @nf + 0.29)')
+ nrd=expr('0.29 / @W ') nrs=expr('0.29 / @W ') sa=0 sb=0 sd=0 mult=1 m=1
XMg20_5 s control v v sky130_fd_pr__pfet_01v8 L=2 W=1 nf=1 ad=expr('int((@nf + 1)/2) * @W / @nf * 0.29')
+ as=expr('int((@nf + 2)/2) * @W / @nf * 0.29') pd=expr('2*int((@nf + 1)/2) * (@W / @nf + 0.29)') ps=expr('2*int((@nf + 2)/2) * (@W / @nf + 0.29)')
+ nrd=expr('0.29 / @W ') nrs=expr('0.29 / @W ') sa=0 sb=0 sd=0 mult=1 m=1
XMg20_6 s control v v sky130_fd_pr__pfet_01v8 L=2 W=1 nf=1 ad=expr('int((@nf + 1)/2) * @W / @nf * 0.29')
+ as=expr('int((@nf + 2)/2) * @W / @nf * 0.29') pd=expr('2*int((@nf + 1)/2) * (@W / @nf + 0.29)') ps=expr('2*int((@nf + 2)/2) * (@W / @nf + 0.29)')
+ nrd=expr('0.29 / @W ') nrs=expr('0.29 / @W ') sa=0 sb=0 sd=0 mult=1 m=1
XMg20_7 s control v v sky130_fd_pr__pfet_01v8 L=2 W=1 nf=1 ad=expr('int((@nf + 1)/2) * @W / @nf * 0.29')
+ as=expr('int((@nf + 2)/2) * @W / @nf * 0.29') pd=expr('2*int((@nf + 1)/2) * (@W / @nf + 0.29)') ps=expr('2*int((@nf + 2)/2) * (@W / @nf + 0.29)')
+ nrd=expr('0.29 / @W ') nrs=expr('0.29 / @W ') sa=0 sb=0 sd=0 mult=1 m=1
XMg20_8 s control v v sky130_fd_pr__pfet_01v8 L=2 W=1 nf=1 ad=expr('int((@nf + 1)/2) * @W / @nf * 0.29')
+ as=expr('int((@nf + 2)/2) * @W / @nf * 0.29') pd=expr('2*int((@nf + 1)/2) * (@W / @nf + 0.29)') ps=expr('2*int((@nf + 2)/2) * (@W / @nf + 0.29)')
+ nrd=expr('0.29 / @W ') nrs=expr('0.29 / @W ') sa=0 sb=0 sd=0 mult=1 m=1
XMg20_9 s control v v sky130_fd_pr__pfet_01v8 L=2 W=1 nf=1 ad=expr('int((@nf + 1)/2) * @W / @nf * 0.29')
+ as=expr('int((@nf + 2)/2) * @W / @nf * 0.29') pd=expr('2*int((@nf + 1)/2) * (@W / @nf + 0.29)') ps=expr('2*int((@nf + 2)/2) * (@W / @nf + 0.29)')
+ nrd=expr('0.29 / @W ') nrs=expr('0.29 / @W ') sa=0 sb=0 sd=0 mult=1 m=1
XMg20_10 s control v v sky130_fd_pr__pfet_01v8 L=2 W=1 nf=1 ad=expr('int((@nf + 1)/2) * @W / @nf * 0.29')
+ as=expr('int((@nf + 2)/2) * @W / @nf * 0.29') pd=expr('2*int((@nf + 1)/2) * (@W / @nf + 0.29)') ps=expr('2*int((@nf + 2)/2) * (@W / @nf + 0.29)')
+ nrd=expr('0.29 / @W ') nrs=expr('0.29 / @W ') sa=0 sb=0 sd=0 mult=1 m=1
XMg20_11 s control v v sky130_fd_pr__pfet_01v8 L=2 W=1 nf=1 ad=expr('int((@nf + 1)/2) * @W / @nf * 0.29')
+ as=expr('int((@nf + 2)/2) * @W / @nf * 0.29') pd=expr('2*int((@nf + 1)/2) * (@W / @nf + 0.29)') ps=expr('2*int((@nf + 2)/2) * (@W / @nf + 0.29)')
+ nrd=expr('0.29 / @W ') nrs=expr('0.29 / @W ') sa=0 sb=0 sd=0 mult=1 m=1
XMg20_12 s control v v sky130_fd_pr__pfet_01v8 L=2 W=1 nf=1 ad=expr('int((@nf + 1)/2) * @W / @nf * 0.29')
+ as=expr('int((@nf + 2)/2) * @W / @nf * 0.29') pd=expr('2*int((@nf + 1)/2) * (@W / @nf + 0.29)') ps=expr('2*int((@nf + 2)/2) * (@W / @nf + 0.29)')
+ nrd=expr('0.29 / @W ') nrs=expr('0.29 / @W ') sa=0 sb=0 sd=0 mult=1 m=1
XMg20_13 s control v v sky130_fd_pr__pfet_01v8 L=2 W=1 nf=1 ad=expr('int((@nf + 1)/2) * @W / @nf * 0.29')
+ as=expr('int((@nf + 2)/2) * @W / @nf * 0.29') pd=expr('2*int((@nf + 1)/2) * (@W / @nf + 0.29)') ps=expr('2*int((@nf + 2)/2) * (@W / @nf + 0.29)')
+ nrd=expr('0.29 / @W ') nrs=expr('0.29 / @W ') sa=0 sb=0 sd=0 mult=1 m=1
XMg20_14 s control v v sky130_fd_pr__pfet_01v8 L=2 W=1 nf=1 ad=expr('int((@nf + 1)/2) * @W / @nf * 0.29')
+ as=expr('int((@nf + 2)/2) * @W / @nf * 0.29') pd=expr('2*int((@nf + 1)/2) * (@W / @nf + 0.29)') ps=expr('2*int((@nf + 2)/2) * (@W / @nf + 0.29)')
+ nrd=expr('0.29 / @W ') nrs=expr('0.29 / @W ') sa=0 sb=0 sd=0 mult=1 m=1
XMg20_15 s control v v sky130_fd_pr__pfet_01v8 L=2 W=1 nf=1 ad=expr('int((@nf + 1)/2) * @W / @nf * 0.29')
+ as=expr('int((@nf + 2)/2) * @W / @nf * 0.29') pd=expr('2*int((@nf + 1)/2) * (@W / @nf + 0.29)') ps=expr('2*int((@nf + 2)/2) * (@W / @nf + 0.29)')
+ nrd=expr('0.29 / @W ') nrs=expr('0.29 / @W ') sa=0 sb=0 sd=0 mult=1 m=1
XMg20_16 s control v v sky130_fd_pr__pfet_01v8 L=2 W=1 nf=1 ad=expr('int((@nf + 1)/2) * @W / @nf * 0.29')
+ as=expr('int((@nf + 2)/2) * @W / @nf * 0.29') pd=expr('2*int((@nf + 1)/2) * (@W / @nf + 0.29)') ps=expr('2*int((@nf + 2)/2) * (@W / @nf + 0.29)')
+ nrd=expr('0.29 / @W ') nrs=expr('0.29 / @W ') sa=0 sb=0 sd=0 mult=1 m=1
XMg20_17 s control v v sky130_fd_pr__pfet_01v8 L=2 W=1 nf=1 ad=expr('int((@nf + 1)/2) * @W / @nf * 0.29')
+ as=expr('int((@nf + 2)/2) * @W / @nf * 0.29') pd=expr('2*int((@nf + 1)/2) * (@W / @nf + 0.29)') ps=expr('2*int((@nf + 2)/2) * (@W / @nf + 0.29)')
+ nrd=expr('0.29 / @W ') nrs=expr('0.29 / @W ') sa=0 sb=0 sd=0 mult=1 m=1
XMg20_18 s control v v sky130_fd_pr__pfet_01v8 L=2 W=1 nf=1 ad=expr('int((@nf + 1)/2) * @W / @nf * 0.29')
+ as=expr('int((@nf + 2)/2) * @W / @nf * 0.29') pd=expr('2*int((@nf + 1)/2) * (@W / @nf + 0.29)') ps=expr('2*int((@nf + 2)/2) * (@W / @nf + 0.29)')
+ nrd=expr('0.29 / @W ') nrs=expr('0.29 / @W ') sa=0 sb=0 sd=0 mult=1 m=1
XMg20_19 s control v v sky130_fd_pr__pfet_01v8 L=2 W=1 nf=1 ad=expr('int((@nf + 1)/2) * @W / @nf * 0.29')
+ as=expr('int((@nf + 2)/2) * @W / @nf * 0.29') pd=expr('2*int((@nf + 1)/2) * (@W / @nf + 0.29)') ps=expr('2*int((@nf + 2)/2) * (@W / @nf + 0.29)')
+ nrd=expr('0.29 / @W ') nrs=expr('0.29 / @W ') sa=0 sb=0 sd=0 mult=1 m=1
XMg20_20 s control v v sky130_fd_pr__pfet_01v8 L=2 W=1 nf=1 ad=expr('int((@nf + 1)/2) * @W / @nf * 0.29')
+ as=expr('int((@nf + 2)/2) * @W / @nf * 0.29') pd=expr('2*int((@nf + 1)/2) * (@W / @nf + 0.29)') ps=expr('2*int((@nf + 2)/2) * (@W / @nf + 0.29)')
+ nrd=expr('0.29 / @W ') nrs=expr('0.29 / @W ') sa=0 sb=0 sd=0 mult=1 m=1
.ends

* expanding   symbol:  bank.sym # of pins=33
** sym_path: /mnt/c/Users/eleva/Documents/ChatGPT/Tiny Tapeout/tt-sky26e-ccro-adc/review/xschem/bank.sym
** sch_path: /mnt/c/Users/eleva/Documents/ChatGPT/Tiny Tapeout/tt-sky26e-ccro-adc/review/xschem/bank.sch
.subckt bank rail well g oa0 ob0 oa1 ob1 oa2 ob2 oa3 ob3 oa4 ob4 oa5 ob5 oa6 ob6 oa7 ob7 oa8 ob8 oa9
+ ob9 oa10 ob10 oa11 ob11 oa12 ob12 oa13 ob13 oa14 ob14
*.PININFO rail:B well:B g:B oa0:B ob0:B oa1:B ob1:B oa2:B ob2:B oa3:B ob3:B oa4:B ob4:B oa5:B ob5:B
*+ oa6:B ob6:B oa7:B ob7:B oa8:B ob8:B oa9:B ob9:B oa10:B ob10:B oa11:B ob11:B oa12:B ob12:B oa13:B ob13:B
*+ oa14:B ob14:B
X0 oa14 ob14 oa0 ob0 rail g well stage
X1 oa0 ob0 oa1 ob1 rail g well stage
X2 oa1 ob1 oa2 ob2 rail g well stage
X3 oa2 ob2 oa3 ob3 rail g well stage
X4 oa3 ob3 oa4 ob4 rail g well stage
X5 oa4 ob4 oa5 ob5 rail g well stage
X6 oa5 ob5 oa6 ob6 rail g well stage
X7 oa6 ob6 oa7 ob7 rail g well stage
X8 oa7 ob7 oa8 ob8 rail g well stage
X9 oa8 ob8 oa9 ob9 rail g well stage
X10 oa9 ob9 oa10 ob10 rail g well stage
X11 oa10 ob10 oa11 ob11 rail g well stage
X12 oa11 ob11 oa12 ob12 rail g well stage
X13 oa12 ob12 oa13 ob13 rail g well stage
X14 oa13 ob13 oa14 ob14 rail g well stage
Xdummy well well dy dz g g well stage
.ends

* expanding   symbol:  cvsl.sym # of pins=5
** sym_path: /mnt/c/Users/eleva/Documents/ChatGPT/Tiny Tapeout/tt-sky26e-ccro-adc/review/xschem/cvsl.sym
** sch_path: /mnt/c/Users/eleva/Documents/ChatGPT/Tiny Tapeout/tt-sky26e-ccro-adc/review/xschem/cvsl.sch
.subckt cvsl a b out v g
*.PININFO a:B b:B out:B v:B g:B
XMn0 l a g g sky130_fd_pr__nfet_01v8_lvt L=.15 W=4 nf=1 ad=1.16 as=1.16 pd=8.58 ps=8.58 nrd=expr('0.29 / @W ')
+ nrs=expr('0.29 / @W ') sa=0 sb=0 sd=0 mult=1 m=1
XMn1 r b g g sky130_fd_pr__nfet_01v8_lvt L=.15 W=4 nf=1 ad=1.16 as=1.16 pd=8.58 ps=8.58 nrd=expr('0.29 / @W ')
+ nrs=expr('0.29 / @W ') sa=0 sb=0 sd=0 mult=1 m=1
XMp0 l r v v sky130_fd_pr__pfet_01v8 L=2.4 W=.42 nf=1 ad=.122 as=.122 pd=1.42 ps=1.42 nrd=expr('0.29 / @W ')
+ nrs=expr('0.29 / @W ') sa=0 sb=0 sd=0 mult=1 m=1
XMp1 r l v v sky130_fd_pr__pfet_01v8 L=2.4 W=.42 nf=1 ad=.122 as=.122 pd=1.42 ps=1.42 nrd=expr('0.29 / @W ')
+ nrs=expr('0.29 / @W ') sa=0 sb=0 sd=0 mult=1 m=1
XMbuf_p out l v v sky130_fd_pr__pfet_01v8 L=.15 W=.84 nf=1 ad=expr('int((@nf + 1)/2) * @W / @nf * 0.29')
+ as=expr('int((@nf + 2)/2) * @W / @nf * 0.29') pd=expr('2*int((@nf + 1)/2) * (@W / @nf + 0.29)') ps=expr('2*int((@nf + 2)/2) * (@W / @nf + 0.29)')
+ nrd=expr('0.29 / @W ') nrs=expr('0.29 / @W ') sa=0 sb=0 sd=0 mult=1 m=1
XMbuf_n out l g g sky130_fd_pr__nfet_01v8 L=.15 W=.42 nf=1 ad=expr('int((@nf + 1)/2) * @W / @nf * 0.29')
+ as=expr('int((@nf + 2)/2) * @W / @nf * 0.29') pd=expr('2*int((@nf + 1)/2) * (@W / @nf + 0.29)') ps=expr('2*int((@nf + 2)/2) * (@W / @nf + 0.29)')
+ nrd=expr('0.29 / @W ') nrs=expr('0.29 / @W ') sa=0 sb=0 sd=0 mult=1 m=1
XMdummy_p dummy r v v sky130_fd_pr__pfet_01v8 L=.15 W=.84 nf=1 ad=expr('int((@nf + 1)/2) * @W / @nf * 0.29')
+ as=expr('int((@nf + 2)/2) * @W / @nf * 0.29') pd=expr('2*int((@nf + 1)/2) * (@W / @nf + 0.29)') ps=expr('2*int((@nf + 2)/2) * (@W / @nf + 0.29)')
+ nrd=expr('0.29 / @W ') nrs=expr('0.29 / @W ') sa=0 sb=0 sd=0 mult=1 m=1
XMdummy_n dummy r g g sky130_fd_pr__nfet_01v8 L=.15 W=.42 nf=1 ad=expr('int((@nf + 1)/2) * @W / @nf * 0.29')
+ as=expr('int((@nf + 2)/2) * @W / @nf * 0.29') pd=expr('2*int((@nf + 1)/2) * (@W / @nf + 0.29)') ps=expr('2*int((@nf + 2)/2) * (@W / @nf + 0.29)')
+ nrd=expr('0.29 / @W ') nrs=expr('0.29 / @W ') sa=0 sb=0 sd=0 mult=1 m=1
.ends

* expanding   symbol:  stage.sym # of pins=7
** sym_path: /mnt/c/Users/eleva/Documents/ChatGPT/Tiny Tapeout/tt-sky26e-ccro-adc/review/xschem/stage.sym
** sch_path: /mnt/c/Users/eleva/Documents/ChatGPT/Tiny Tapeout/tt-sky26e-ccro-adc/review/xschem/stage.sch
.subckt stage a b y z rail g well
*.PININFO a:B b:B y:B z:B rail:B g:B well:B
XCca g y sky130_fd_pr__cap_mim_m3_1 W=4.5 L=4.5 MF=1 m=1
XCcb g z sky130_fd_pr__cap_mim_m3_1 W=4.5 L=4.5 MF=1 m=1
XMmainA_Xp y a rail well sky130_fd_pr__pfet_01v8_lvt L=.55 W=8.4 nf=1 ad=expr('int((@nf + 1)/2) * @W / @nf * 0.29')
+ as=expr('int((@nf + 2)/2) * @W / @nf * 0.29') pd=expr('2*int((@nf + 1)/2) * (@W / @nf + 0.29)') ps=expr('2*int((@nf + 2)/2) * (@W / @nf + 0.29)')
+ nrd=expr('0.29 / @W ') nrs=expr('0.29 / @W ') sa=0 sb=0 sd=0 mult=1 m=1
XMmainA_Xn y a g g sky130_fd_pr__nfet_01v8 L=.55 W=4.2 nf=1 ad=expr('int((@nf + 1)/2) * @W / @nf * 0.29')
+ as=expr('int((@nf + 2)/2) * @W / @nf * 0.29') pd=expr('2*int((@nf + 1)/2) * (@W / @nf + 0.29)') ps=expr('2*int((@nf + 2)/2) * (@W / @nf + 0.29)')
+ nrd=expr('0.29 / @W ') nrs=expr('0.29 / @W ') sa=0 sb=0 sd=0 mult=1 m=1
XMmainB_Xp z b rail well sky130_fd_pr__pfet_01v8_lvt L=.55 W=8.4 nf=1 ad=expr('int((@nf + 1)/2) * @W / @nf * 0.29')
+ as=expr('int((@nf + 2)/2) * @W / @nf * 0.29') pd=expr('2*int((@nf + 1)/2) * (@W / @nf + 0.29)') ps=expr('2*int((@nf + 2)/2) * (@W / @nf + 0.29)')
+ nrd=expr('0.29 / @W ') nrs=expr('0.29 / @W ') sa=0 sb=0 sd=0 mult=1 m=1
XMmainB_Xn z b g g sky130_fd_pr__nfet_01v8 L=.55 W=4.2 nf=1 ad=expr('int((@nf + 1)/2) * @W / @nf * 0.29')
+ as=expr('int((@nf + 2)/2) * @W / @nf * 0.29') pd=expr('2*int((@nf + 1)/2) * (@W / @nf + 0.29)') ps=expr('2*int((@nf + 2)/2) * (@W / @nf + 0.29)')
+ nrd=expr('0.29 / @W ') nrs=expr('0.29 / @W ') sa=0 sb=0 sd=0 mult=1 m=1
XMcrossA_Xp z y rail well sky130_fd_pr__pfet_01v8_lvt L=.55 W=1.68 nf=1 ad=expr('int((@nf + 1)/2) * @W / @nf * 0.29')
+ as=expr('int((@nf + 2)/2) * @W / @nf * 0.29') pd=expr('2*int((@nf + 1)/2) * (@W / @nf + 0.29)') ps=expr('2*int((@nf + 2)/2) * (@W / @nf + 0.29)')
+ nrd=expr('0.29 / @W ') nrs=expr('0.29 / @W ') sa=0 sb=0 sd=0 mult=1 m=1
XMcrossA_Xn z y g g sky130_fd_pr__nfet_01v8 L=.55 W=.84 nf=1 ad=expr('int((@nf + 1)/2) * @W / @nf * 0.29')
+ as=expr('int((@nf + 2)/2) * @W / @nf * 0.29') pd=expr('2*int((@nf + 1)/2) * (@W / @nf + 0.29)') ps=expr('2*int((@nf + 2)/2) * (@W / @nf + 0.29)')
+ nrd=expr('0.29 / @W ') nrs=expr('0.29 / @W ') sa=0 sb=0 sd=0 mult=1 m=1
XMcrossB_Xp y z rail well sky130_fd_pr__pfet_01v8_lvt L=.55 W=1.68 nf=1 ad=expr('int((@nf + 1)/2) * @W / @nf * 0.29')
+ as=expr('int((@nf + 2)/2) * @W / @nf * 0.29') pd=expr('2*int((@nf + 1)/2) * (@W / @nf + 0.29)') ps=expr('2*int((@nf + 2)/2) * (@W / @nf + 0.29)')
+ nrd=expr('0.29 / @W ') nrs=expr('0.29 / @W ') sa=0 sb=0 sd=0 mult=1 m=1
XMcrossB_Xn y z g g sky130_fd_pr__nfet_01v8 L=.55 W=.84 nf=1 ad=expr('int((@nf + 1)/2) * @W / @nf * 0.29')
+ as=expr('int((@nf + 2)/2) * @W / @nf * 0.29') pd=expr('2*int((@nf + 1)/2) * (@W / @nf + 0.29)') ps=expr('2*int((@nf + 2)/2) * (@W / @nf + 0.29)')
+ nrd=expr('0.29 / @W ') nrs=expr('0.29 / @W ') sa=0 sb=0 sd=0 mult=1 m=1
.ends

.end
